* Intended schematic from supplied transistor connections.
* SKY130 model files use um-scale W/L convention; load the course model setup.
.subckt dd2_g5__inv_1 A VGND VNB VPB VPWR Y
XN1 Y A VGND VNB sky130_fd_pr__nfet_01v8 w=0.65 l=0.15
XP1 Y A VPWR VPB sky130_fd_pr__pfet_01v8_hvt w=1 l=0.15
.ends dd2_g5__inv_1
