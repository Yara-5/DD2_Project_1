* Broken case for transistor_level_check.py: the RC-extracted dd2_g5__nand2_1 with the
* pull-up controlled by A (X2) deleted, so Y floats for A=0, B=1.
* NGSPICE file created from dd2_g5__nand2_1.ext - technology: sky130A

.subckt dd2_g5__nand2_1 A B VGND VNB VPB VPWR Y
X0 Y.t0 B.t1 VPWR.t0 VPB.t0 sky130_fd_pr__pfet_01v8_hvt ad=0.32 pd=2.64 as=0.245 ps=1.49 w=1 l=0.15
X1 a_187_47.t1 A.t0 Y.t2 VNB.t1 sky130_fd_pr__nfet_01v8 ad=0.15925 pd=1.14 as=0.208 ps=1.94 w=0.65 l=0.15
X3 VGND.t0 B.t0 a_187_47.t0 VNB.t0 sky130_fd_pr__nfet_01v8 ad=0.208 pd=1.94 as=0.15925 ps=1.14 w=0.65 l=0.15
R0 VGND.n0 VGND.t0 239.304
R1 VGND VGND.n0 14.3384
R2 VGND.n0 VGND 0.089931
R3 VPWR.n1 VPWR.n0 606.894
R4 VPWR.n0 VPWR.t0 48.2655
R5 VPWR.n0 VPWR.t1 48.2655
R6 VPWR VPWR.n1 14.075
R7 VPWR.n1 VPWR 0.338899
R8 Y.n1 Y.t0 785.078
R9 Y.n0 Y.t1 785.078
R10 Y.n0 Y.t2 284.192
R11 Y.n1 Y.n0 73.7887
R12 Y Y.n1 73.1385
R13 B.n0 B.t1 236.18
R14 B.n0 B.t0 163.881
R15 B B.n0 155.492
R16 A.n0 A.t1 236.18
R17 A.n0 A.t0 163.881
R18 A A.n0 155.492
R19 VPB VPB.t1 426.168
R20 VPB.t1 VPB.t0 378.817
R21 VNB VNB.t1 2050.49
R22 VNB.t1 VNB.t0 1822.65
R23 a_187_47.t0 a_187_47.t1 90.462
C0 VPWR A 0.01849f
C1 VGND A 0.01948f
C2 VGND VPWR 0.03133f
C3 Y A 0.04959f
C4 A B 0.02652f
C5 Y VPWR 0.08888f
C6 Y VGND 0.05018f
C7 VPWR B 0.01877f
C8 VGND B 0.0264f
C9 VPB A 0.03794f
C10 Y B 0.03338f
C11 VPWR VPB 0.10511f
C12 VGND VPB 0.01918f
C13 Y VPB 0.04717f
C14 VPB B 0.03941f
C15 VGND VNB 0.45398f
C16 VPWR VNB 0.45029f
C17 Y VNB 0.14843f
C18 B VNB 0.12177f
C19 A VNB 0.12225f
C20 VPB VNB 0.65944f
C21 a_187_47.t1 VNB 0.03069f
C22 a_187_47.t0 VNB 0.02994f
C23 VPB.t0 VNB 0.14026f
C24 VPB.t1 VNB 0.05388f
C25 A.n0 VNB 0.04957f
C26 B.n0 VNB 0.04714f
C27 Y.t2 VNB 0.05327f
C28 Y.t1 VNB 0.06877f
C29 Y.n0 VNB 0.07019f
C30 Y.t0 VNB 0.06772f
C31 Y.n1 VNB 0.0456f
C32 VPWR.t0 VNB 0.03358f
C33 VPWR.t1 VNB 0.03463f
C34 VPWR.n0 VNB 0.0272f
C35 VPWR.n1 VNB 0.06198f
C36 VGND.t0 VNB 0.03023f
C37 VGND.n0 VNB 0.08835f
.ends
