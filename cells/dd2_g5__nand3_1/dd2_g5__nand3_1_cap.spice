* NGSPICE file created from dd2_g5__nand3_1.ext - technology: sky130A

.subckt dd2_g5__nand3_1 A B C VGND VNB VPB VPWR Y
X0 VPWR C Y VPB sky130_fd_pr__pfet_01v8_hvt ad=0.26 pd=2.52 as=0.155 ps=1.31 w=1 l=0.15
X1 VPWR A Y VPB sky130_fd_pr__pfet_01v8_hvt ad=0.135 pd=1.27 as=0.26 ps=2.52 w=1 l=0.15
X2 a_195_47# B a_111_47# VNB sky130_fd_pr__nfet_01v8 ad=0.10075 pd=0.96 as=0.08775 ps=0.92 w=0.65 l=0.15
X3 a_111_47# A Y VNB sky130_fd_pr__nfet_01v8 ad=0.08775 pd=0.92 as=0.169 ps=1.82 w=0.65 l=0.15
X4 Y B VPWR VPB sky130_fd_pr__pfet_01v8_hvt ad=0.155 pd=1.31 as=0.135 ps=1.27 w=1 l=0.15
X5 VGND C a_195_47# VNB sky130_fd_pr__nfet_01v8 ad=0.169 pd=1.82 as=0.10075 ps=0.96 w=0.65 l=0.15
C0 Y B 0.05699f
C1 VGND VPB 0.00775f
C2 A VPB 0.02938f
C3 a_111_47# VPWR 0
C4 VGND B 0.01332f
C5 A B 0.03922f
C6 C VPB 0.03813f
C7 C B 0.02424f
C8 Y VPWR 0.06076f
C9 Y a_111_47# 0.00825f
C10 VGND VPWR 0.02464f
C11 B a_195_47# 0
C12 VPWR A 0.01694f
C13 B VPB 0.02563f
C14 C VPWR 0.02659f
C15 VGND a_111_47# 0.00654f
C16 VPWR a_195_47# 0
C17 Y VGND 0.04891f
C18 Y A 0.0408f
C19 VPWR VPB 0.06357f
C20 Y C 0.03157f
C21 VPWR B 0.01872f
C22 VGND A 0.01249f
C23 a_111_47# B 0
C24 VGND C 0.02629f
C25 Y a_195_47# 0.00892f
C26 Y VPB 0.017f
C27 VGND a_195_47# 0.00804f
C28 VGND VNB 0.26599f
C29 VPWR VNB 0.33165f
C30 Y VNB 0.17827f
C31 VPB VNB 0.42757f
C32 a_195_47# VNB 0.02768f
C33 a_111_47# VNB 0.02768f
.ends
