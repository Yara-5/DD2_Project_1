* NGSPICE file created from dd2_g5__nand3_1.ext - technology: sky130A

.subckt dd2_g5__nand3_1 A B C VGND VNB VPB VPWR Y
X0 VPWR C Y VPB sky130_fd_pr__pfet_01v8_hvt ad=0.26 pd=2.52 as=0.155 ps=1.31 w=1 l=0.15
X1 VPWR A Y VPB sky130_fd_pr__pfet_01v8_hvt ad=0.135 pd=1.27 as=0.26 ps=2.52 w=1 l=0.15
X2 a_195_47# B a_111_47# VNB sky130_fd_pr__nfet_01v8 ad=0.10075 pd=0.96 as=0.08775 ps=0.92 w=0.65 l=0.15
X3 a_111_47# A Y VNB sky130_fd_pr__nfet_01v8 ad=0.08775 pd=0.92 as=0.169 ps=1.82 w=0.65 l=0.15
X4 Y B VPWR VPB sky130_fd_pr__pfet_01v8_hvt ad=0.155 pd=1.31 as=0.135 ps=1.27 w=1 l=0.15
X5 VGND C a_195_47# VNB sky130_fd_pr__nfet_01v8 ad=0.169 pd=1.82 as=0.10075 ps=0.96 w=0.65 l=0.15
C0 VGND VPWR 0.02393f
C1 B a_195_47# 0
C2 VPWR A 0.0178f
C3 B VPB 0.02563f
C4 C VPWR 0.0287f
C5 VGND a_111_47# 0.00654f
C6 VPWR a_195_47# 0
C7 Y VGND 0.05998f
C8 Y A 0.04905f
C9 VPWR VPB 0.05876f
C10 Y C 0.03727f
C11 VPWR B 0.02013f
C12 VGND A 0.01159f
C13 a_111_47# B 0
C14 VGND C 0.02624f
C15 Y a_195_47# 0.0101f
C16 Y VPB 0.02042f
C17 VGND a_195_47# 0.00804f
C18 Y B 0.06399f
C19 VGND VPB 0.00672f
C20 A VPB 0.02938f
C21 a_111_47# VPWR 0
C22 VGND B 0.01326f
C23 C VPB 0.03813f
C24 A B 0.03922f
C25 C B 0.02424f
C26 Y VPWR 0.15159f
C27 Y a_111_47# 0.00971f
C28 VGND VNB 0.26197f
C29 VPWR VNB 0.3368f
C30 Y VNB 0.20986f
C31 VPB VNB 0.42757f
C32 a_195_47# VNB 0.02768f
C33 a_111_47# VNB 0.02768f
.ends
