* NGSPICE file created from dd2_g5__nand3_1.ext - technology: sky130A

.subckt dd2_g5__nand3_1 A B C VGND VNB VPB VPWR Y
X0 VPWR.t0 C.t1 Y.t0 VPB.t1 sky130_fd_pr__pfet_01v8_hvt ad=0.26 pd=2.52 as=0.155 ps=1.31 w=1 l=0.15
X1 VPWR.t1 A.t1 Y.t1 VPB.t0 sky130_fd_pr__pfet_01v8_hvt ad=0.135 pd=1.27 as=0.26 ps=2.52 w=1 l=0.15
X2 a_195_47.t1 B.t0 a_111_47.t1 VNB.t2 sky130_fd_pr__nfet_01v8 ad=0.10075 pd=0.96 as=0.08775 ps=0.92 w=0.65 l=0.15
X3 a_111_47.t0 A.t0 Y.t3 VNB.t0 sky130_fd_pr__nfet_01v8 ad=0.08775 pd=0.92 as=0.169 ps=1.82 w=0.65 l=0.15
X4 Y.t2 B.t1 VPWR.t2 VPB.t2 sky130_fd_pr__pfet_01v8_hvt ad=0.155 pd=1.31 as=0.135 ps=1.27 w=1 l=0.15
X5 VGND.t0 C.t0 a_195_47.t0 VNB.t1 sky130_fd_pr__nfet_01v8 ad=0.169 pd=1.82 as=0.10075 ps=0.96 w=0.65 l=0.15
R0 VGND.n0 VGND.t0 289.916
R1 VGND VGND.n0 14.302
R2 VGND.n0 VGND 0.125759
R3 VPWR.n2 VPWR.t0 885.337
R4 VPWR.n1 VPWR.n0 607.212
R5 VPWR.n4 VPWR.n1 34.6358
R6 VPWR.n0 VPWR.t1 26.5955
R7 VPWR.n0 VPWR.t2 26.5955
R8 VPWR.n4 VPWR.n3 9.3005
R9 VPWR.n2 VPWR.n1 7.21807
R10 VPWR VPWR.n4 6.77697
R11 VPWR.n3 VPWR.n2 0.531936
R12 VPWR.n3 VPWR 0.0239375
R13 Y.n1 Y.t1 896.004
R14 Y.n1 Y.n0 585
R15 Y.n2 Y.t3 209.923
R16 Y.n2 Y.n1 131.766
R17 Y.n0 Y.t0 30.5355
R18 Y.n0 Y.t2 30.5355
R19 Y.n2 Y 6.4005
R20 Y Y.n2 6.02403
R21 C.n0 C.t1 230.155
R22 C.n0 C.t0 157.856
R23 C C.n0 155.103
R24 B.n0 B.t1 241.536
R25 B.n0 B.t0 169.237
R26 B B.n0 155.103
R27 A.n0 A.t1 241.536
R28 A.n0 A.t0 169.237
R29 A A.n0 155.103
R30 VPB.t2 VPB.t1 272.274
R31 VPB.t0 VPB.t2 248.599
R32 VPB VPB.t0 201.246
R33 VNB.t2 VNB.t1 1310.03
R34 VNB.t0 VNB.t2 1196.12
R35 VNB VNB.t0 968.285
R36 a_195_47.t0 a_195_47.t1 57.2313
R37 a_111_47.t0 a_111_47.t1 49.8467
C0 Y VPB 0.017f
C1 C VPB 0.03813f
C2 VPB VPWR 0.06357f
C3 B VGND 0.01332f
C4 B A 0.03922f
C5 B VPB 0.02563f
C6 C Y 0.03157f
C7 Y VPWR 0.06076f
C8 C VPWR 0.02659f
C9 VGND A 0.01249f
C10 VGND VPB 0.00775f
C11 A VPB 0.02938f
C12 B Y 0.05699f
C13 C B 0.02424f
C14 B VPWR 0.01872f
C15 VGND Y 0.04891f
C16 C VGND 0.02629f
C17 VGND VPWR 0.02464f
C18 Y A 0.0408f
C19 A VPWR 0.01694f
C20 VGND VNB 0.33634f
C21 VPWR VNB 0.24168f
C22 Y VNB 0.07925f
C23 C VNB 0.12854f
C24 B VNB 0.0767f
C25 A VNB 0.11199f
C26 VPB VNB 0.46844f
C27 a_111_47.t1 VNB 0.02867f
C28 a_111_47.t0 VNB 0.02407f
C29 a_195_47.t1 VNB 0.02978f
C30 a_195_47.t0 VNB 0.02406f
C31 VPB.t1 VNB 0.07356f
C32 VPB.t2 VNB 0.03596f
C33 VPB.t0 VNB 0.03106f
C34 A.n0 VNB 0.0452f
C35 B.n0 VNB 0.058f
C36 C.n0 VNB 0.05934f
C37 Y.t1 VNB 0.07291f
C38 Y.t0 VNB 0.03696f
C39 Y.t2 VNB 0.04483f
C40 Y.n0 VNB 0.03203f
C41 Y.n1 VNB 0.0829f
C42 Y.t3 VNB 0.04808f
C43 Y.n2 VNB 0.04086f
C44 VPWR.t2 VNB 0.03645f
C45 VPWR.t1 VNB 0.03009f
C46 VPWR.n0 VNB 0.0155f
C47 VPWR.n1 VNB 0.01864f
C48 VPWR.t0 VNB 0.04783f
C49 VPWR.n2 VNB 0.04616f
C50 VPWR.n3 VNB 0.07165f
C51 VPWR.n4 VNB 0.00529f
C52 VGND.t0 VNB 0.03125f
C53 VGND.n0 VNB 0.06551f
.ends
