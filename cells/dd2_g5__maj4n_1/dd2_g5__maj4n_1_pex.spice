* NGSPICE file created from dd2_g5__maj4n_1.ext - technology: sky130A

.subckt dd2_g5__maj4n_1 A B C D VGND VNB VPB VPWR Y
X0 a_683_47.t1 C.t0 Y.t0 VNB.t3 sky130_fd_pr__nfet_01v8 ad=0.17225 pd=1.18 as=0.17875 ps=1.2 w=0.65 l=0.15
X1 VGND.t0 D.t0 a_683_47.t0 VNB.t1 sky130_fd_pr__nfet_01v8 ad=0.169 pd=1.82 as=0.17225 ps=1.18 w=0.65 l=0.15
X2 VPWR.t1 C.t2 a_267_297.t2 VPB.t3 sky130_fd_pr__pfet_01v8_hvt ad=0.265 pd=1.53 as=0.275 ps=1.55 w=1 l=0.15
X3 a_267_297.t0 D.t2 VPWR.t0 VPB.t1 sky130_fd_pr__pfet_01v8_hvt ad=0.26 pd=2.52 as=0.265 ps=1.53 w=1 l=0.15
X4 Y.t1 A.t1 a_267_297.t4 VPB.t5 sky130_fd_pr__pfet_01v8_hvt ad=0.265 pd=1.53 as=0.275 ps=1.55 w=1 l=0.15
X5 VGND.t2 C.t1 a_49_47.t1 VNB.t2 sky130_fd_pr__nfet_01v8 ad=0.17225 pd=1.18 as=0.169 ps=1.82 w=0.65 l=0.15
X6 a_267_297.t3 B.t1 Y.t3 VPB.t4 sky130_fd_pr__pfet_01v8_hvt ad=0.275 pd=1.55 as=0.265 ps=1.53 w=1 l=0.15
X7 a_49_47.t0 D.t1 VGND.t1 VNB.t0 sky130_fd_pr__nfet_01v8 ad=0.17875 pd=1.2 as=0.17225 ps=1.18 w=0.65 l=0.15
X8 Y.t2 B.t0 a_407_47.t0 VNB.t4 sky130_fd_pr__nfet_01v8 ad=0.17875 pd=1.2 as=0.17225 ps=1.18 w=0.65 l=0.15
X9 a_131_297.t1 C.t3 Y.t4 VPB.t2 sky130_fd_pr__pfet_01v8_hvt ad=0.265 pd=1.53 as=0.26 ps=2.52 w=1 l=0.15
X10 a_267_297.t1 D.t3 a_131_297.t0 VPB.t0 sky130_fd_pr__pfet_01v8_hvt ad=0.275 pd=1.55 as=0.265 ps=1.53 w=1 l=0.15
X11 a_407_47.t1 A.t0 a_49_47.t2 VNB.t5 sky130_fd_pr__nfet_01v8 ad=0.17225 pd=1.18 as=0.17875 ps=1.2 w=0.65 l=0.15
R0 VGND.n2 VGND.n1 199.739
R1 VGND.n3 VGND.t0 156.77
R2 VGND.n1 VGND.t2 48.9236
R3 VGND.n1 VGND.t1 48.9236
R4 VGND.n6 VGND.n0 34.6358
R5 VGND.n3 VGND.n2 12.4951
R6 VGND.n4 VGND.n0 9.3005
R7 VGND.n6 VGND.n5 9.3005
R8 VGND VGND.n6 6.77697
R9 VGND.n2 VGND.n0 4.89462
R10 VGND.n4 VGND.n3 0.147287
R11 VGND.n5 VGND.n4 0.120292
R12 VGND.n5 VGND 0.0239375
R13 VPWR.n1 VPWR.n0 620.518
R14 VPWR.n0 VPWR.t0 52.2055
R15 VPWR.n0 VPWR.t1 52.2055
R16 VPWR VPWR.n1 14.3776
R17 VPWR.n1 VPWR 0.0508605
R18 Y.n1 Y.t4 355.574
R19 Y.n1 Y.n0 208.507
R20 Y Y.n3 191.982
R21 Y.n3 Y.n2 188.103
R22 Y.n2 Y.n1 101.106
R23 Y.n0 Y.t1 52.2055
R24 Y.n0 Y.t3 52.2055
R25 Y.n3 Y.t2 50.7697
R26 Y.n3 Y.t0 50.7697
R27 Y Y.n2 3.10353
R28 B.n0 B.t1 241.536
R29 B.n0 B.t0 169.237
R30 B B.n0 155.103
R31 A.n0 A.t1 241.536
R32 A.n0 A.t0 169.237
R33 A A.n0 155.103
R34 D.n1 D.t3 241.536
R35 D.n0 D.t2 241.536
R36 D.n2 D.n0 173.127
R37 D.n1 D.t1 169.237
R38 D.n0 D.t0 169.237
R39 D.n2 D.n1 152
R40 D D.n2 3.10353
R41 C.n1 C.t3 241.536
R42 C.n0 C.t2 241.536
R43 C.n2 C.n0 175.787
R44 C.n1 C.t1 169.237
R45 C.n0 C.t0 169.237
R46 C.n2 C.n1 152
R47 C C.n2 3.10353
R48 VPB.t4 VPB.t3 414.33
R49 VPB.t0 VPB.t5 414.33
R50 VPB.t3 VPB.t1 402.493
R51 VPB.t5 VPB.t4 402.493
R52 VPB.t2 VPB.t0 402.493
R53 VPB VPB.t2 260.437
R54 VNB.t4 VNB.t3 1993.53
R55 VNB.t0 VNB.t5 1993.53
R56 VNB.t3 VNB.t1 1936.57
R57 VNB.t5 VNB.t4 1936.57
R58 VNB.t2 VNB.t0 1936.57
R59 VNB VNB.t2 1253.07
R60 a_683_47.t0 a_683_47.t1 97.8467
R61 a_407_47.t0 a_407_47.t1 97.8467
R62 a_49_47.n0 a_49_47.t1 298.274
R63 a_49_47.n0 a_49_47.t2 50.7697
R64 a_49_47.t0 a_49_47.n0 50.7697
R65 a_267_297.n2 a_267_297.n1 318.747
R66 a_267_297.t0 a_267_297.n2 275.827
R67 a_267_297.n2 a_267_297.n0 195.16
R68 a_267_297.n1 a_267_297.t4 54.1755
R69 a_267_297.n1 a_267_297.t1 54.1755
R70 a_267_297.n0 a_267_297.t2 54.1755
R71 a_267_297.n0 a_267_297.t3 54.1755
R72 a_131_297.t0 a_131_297.t1 104.41
C0 A Y 0.04711f
C1 VGND D 0.071f
C2 D VPWR 0.0265f
C3 VPB C 0.07902f
C4 D A 0.03648f
C5 Y C 0.11129f
C6 D C 0.35018f
C7 VGND VPWR 0.00863f
C8 VPB B 0.03232f
C9 VGND A 0.01618f
C10 Y B 0.04601f
C11 A VPWR 0.00949f
C12 D B 0.01086f
C13 VGND C 0.10333f
C14 VPWR C 0.08552f
C15 A C 0.00391f
C16 VPB Y 0.02807f
C17 VPB D 0.07781f
C18 D Y 0.07305f
C19 VGND B 0.01115f
C20 B VPWR 0.0122f
C21 A B 0.01429f
C22 B C 0.02869f
C23 VGND VPB 0.01216f
C24 VPB VPWR 0.11562f
C25 VGND Y 0.06455f
C26 Y VPWR 0.07249f
C27 VPB A 0.03225f
C28 VGND VNB 0.58372f
C29 VPWR VNB 0.46668f
C30 Y VNB 0.09285f
C31 B VNB 0.08777f
C32 A VNB 0.08834f
C33 D VNB 0.19197f
C34 C VNB 0.26939f
C35 VPB VNB 1.0034f
C36 a_131_297.t1 VNB 0.06914f
C37 a_131_297.t0 VNB 0.0672f
C38 a_267_297.t2 VNB 0.07189f
C39 a_267_297.t3 VNB 0.06153f
C40 a_267_297.n0 VNB 0.06919f
C41 a_267_297.t4 VNB 0.06229f
C42 a_267_297.t1 VNB 0.06996f
C43 a_267_297.n1 VNB 0.0759f
C44 a_267_297.n2 VNB 0.30203f
C45 a_267_297.t0 VNB 0.11314f
C46 a_49_47.t2 VNB 0.03999f
C47 a_49_47.t1 VNB 0.10867f
C48 a_49_47.n0 VNB 0.10529f
C49 a_49_47.t0 VNB 0.04553f
C50 a_407_47.t1 VNB 0.03873f
C51 a_407_47.t0 VNB 0.03818f
C52 a_683_47.t1 VNB 0.04666f
C53 a_683_47.t0 VNB 0.04526f
C54 VPB.t1 VNB 0.08932f
C55 VPB.t3 VNB 0.05552f
C56 VPB.t4 VNB 0.05552f
C57 VPB.t5 VNB 0.05552f
C58 VPB.t0 VNB 0.05552f
C59 VPB.t2 VNB 0.04506f
C60 C.n0 VNB 0.11531f
C61 C.n1 VNB 0.07503f
C62 C.n2 VNB 0.54868f
C63 D.n0 VNB 0.09233f
C64 D.n1 VNB 0.07115f
C65 D.n2 VNB 0.31924f
C66 A.n0 VNB 0.05611f
C67 B.n0 VNB 0.05458f
C68 Y.t4 VNB 0.145f
C69 Y.t3 VNB 0.06234f
C70 Y.t1 VNB 0.0631f
C71 Y.n0 VNB 0.07543f
C72 Y.n1 VNB 0.21786f
C73 Y.n2 VNB 0.05052f
C74 Y.t0 VNB 0.05085f
C75 Y.t2 VNB 0.04336f
C76 Y.n3 VNB 0.04826f
C77 VPWR.t0 VNB 0.05718f
C78 VPWR.t1 VNB 0.05911f
C79 VPWR.n0 VNB 0.04453f
C80 VPWR.n1 VNB 0.45863f
C81 VGND.n0 VNB 0.00512f
C82 VGND.t0 VNB 0.04661f
C83 VGND.t1 VNB 0.03558f
C84 VGND.t2 VNB 0.03698f
C85 VGND.n1 VNB 0.02054f
C86 VGND.n2 VNB 0.02564f
C87 VGND.n3 VNB 0.28628f
C88 VGND.n4 VNB 0.03117f
C89 VGND.n5 VNB 0.01515f
C90 VGND.n6 VNB 0.00537f
.ends
