* dd2_g5__maj4n_1: Y = ((!C & !D) | !A | !B) & (!C | !D)
* Generated by synthesize.py; stages in signal order:
*   Y = !(((C | D) & A & B) | (C & D))
.subckt dd2_g5__maj4n_1 A B C D VGND VNB VPB VPWR Y
XN1 Y C Y_d1 VNB sky130_fd_pr__nfet_01v8 w=0.65 l=0.15
XN2 Y D Y_d1 VNB sky130_fd_pr__nfet_01v8 w=0.65 l=0.15
XN3 Y_d1 A Y_d2 VNB sky130_fd_pr__nfet_01v8 w=0.65 l=0.15
XN4 Y_d2 B VGND VNB sky130_fd_pr__nfet_01v8 w=0.65 l=0.15
XN5 Y C Y_d3 VNB sky130_fd_pr__nfet_01v8 w=0.65 l=0.15
XN6 Y_d3 D VGND VNB sky130_fd_pr__nfet_01v8 w=0.65 l=0.15
XP1 Y_u2 C VPWR VPB sky130_fd_pr__pfet_01v8_hvt w=1 l=0.15
XP2 Y_u1 D Y_u2 VPB sky130_fd_pr__pfet_01v8_hvt w=1 l=0.15
XP3 Y_u1 A VPWR VPB sky130_fd_pr__pfet_01v8_hvt w=1 l=0.15
XP4 Y_u1 B VPWR VPB sky130_fd_pr__pfet_01v8_hvt w=1 l=0.15
XP5 Y C Y_u1 VPB sky130_fd_pr__pfet_01v8_hvt w=1 l=0.15
XP6 Y D Y_u1 VPB sky130_fd_pr__pfet_01v8_hvt w=1 l=0.15
.ends dd2_g5__maj4n_1
