* Intended schematic from supplied transistor connections.
* SKY130 model files use um-scale W/L convention; load the course model setup.
.subckt dd2_g5__maj4n_1 A B C D VGND VNB VPB VPWR Y
XN1 Y_d2 C VGND VNB sky130_fd_pr__nfet_01v8 w=0.65 l=0.15
XN2 Y_d2 D VGND VNB sky130_fd_pr__nfet_01v8 w=0.65 l=0.15
XN3 Y_d1 A Y_d2 VNB sky130_fd_pr__nfet_01v8 w=0.65 l=0.15
XN4 Y B Y_d1 VNB sky130_fd_pr__nfet_01v8 w=0.65 l=0.15
XN5 Y C Y_d3 VNB sky130_fd_pr__nfet_01v8 w=0.65 l=0.15
XN6 Y_d3 D VGND VNB sky130_fd_pr__nfet_01v8 w=0.65 l=0.15
XP1 Y_u2 C Y VPB sky130_fd_pr__pfet_01v8_hvt w=1 l=0.15
XP2 Y_u1 D Y_u2 VPB sky130_fd_pr__pfet_01v8_hvt w=1 l=0.15
XP3 Y_u1 A Y VPB sky130_fd_pr__pfet_01v8_hvt w=1 l=0.15
XP4 Y_u1 B Y VPB sky130_fd_pr__pfet_01v8_hvt w=1 l=0.15
XP5 VPWR C Y_u1 VPB sky130_fd_pr__pfet_01v8_hvt w=1 l=0.15
XP6 VPWR D Y_u1 VPB sky130_fd_pr__pfet_01v8_hvt w=1 l=0.15
.ends dd2_g5__maj4n_1
