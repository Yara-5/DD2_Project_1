* NGSPICE file created from dd2_g5__maj4n_1.ext - technology: sky130A

.subckt dd2_g5__maj4n_1 A B C D VGND VNB VPB VPWR Y
X0 a_683_47# C Y VNB sky130_fd_pr__nfet_01v8 ad=0.17225 pd=1.18 as=0.17875 ps=1.2 w=0.65 l=0.15
X1 VGND D a_683_47# VNB sky130_fd_pr__nfet_01v8 ad=0.169 pd=1.82 as=0.17225 ps=1.18 w=0.65 l=0.15
X2 VPWR C a_267_297# VPB sky130_fd_pr__pfet_01v8_hvt ad=0.265 pd=1.53 as=0.275 ps=1.55 w=1 l=0.15
X3 a_267_297# D VPWR VPB sky130_fd_pr__pfet_01v8_hvt ad=0.26 pd=2.52 as=0.265 ps=1.53 w=1 l=0.15
X4 Y A a_267_297# VPB sky130_fd_pr__pfet_01v8_hvt ad=0.265 pd=1.53 as=0.275 ps=1.55 w=1 l=0.15
X5 VGND C a_49_47# VNB sky130_fd_pr__nfet_01v8 ad=0.17225 pd=1.18 as=0.169 ps=1.82 w=0.65 l=0.15
X6 a_267_297# B Y VPB sky130_fd_pr__pfet_01v8_hvt ad=0.275 pd=1.55 as=0.265 ps=1.53 w=1 l=0.15
X7 a_49_47# D VGND VNB sky130_fd_pr__nfet_01v8 ad=0.17875 pd=1.2 as=0.17225 ps=1.18 w=0.65 l=0.15
X8 Y B a_407_47# VNB sky130_fd_pr__nfet_01v8 ad=0.17875 pd=1.2 as=0.17225 ps=1.18 w=0.65 l=0.15
X9 a_131_297# C Y VPB sky130_fd_pr__pfet_01v8_hvt ad=0.265 pd=1.53 as=0.26 ps=2.52 w=1 l=0.15
X10 a_267_297# D a_131_297# VPB sky130_fd_pr__pfet_01v8_hvt ad=0.275 pd=1.55 as=0.265 ps=1.53 w=1 l=0.15
X11 a_407_47# A a_49_47# VNB sky130_fd_pr__nfet_01v8 ad=0.17225 pd=1.18 as=0.17875 ps=1.2 w=0.65 l=0.15
C0 a_407_47# Y 0.01717f
C1 D a_267_297# 0.05081f
C2 B D 0.01086f
C3 VPB Y 0.02807f
C4 a_131_297# VPWR 0.0173f
C5 B a_267_297# 0.01142f
C6 VPB A 0.03225f
C7 D Y 0.07305f
C8 a_49_47# VPWR 0
C9 Y a_267_297# 0.11755f
C10 C a_683_47# 0.00752f
C11 VGND a_683_47# 0.02112f
C12 B Y 0.04601f
C13 D A 0.03648f
C14 C a_407_47# 0
C15 VGND a_407_47# 0.01142f
C16 A a_267_297# 0.00807f
C17 B A 0.01429f
C18 VPB C 0.07902f
C19 VPB VGND 0.01216f
C20 Y A 0.04711f
C21 a_49_47# a_131_297# 0
C22 C D 0.35018f
C23 VGND D 0.071f
C24 C a_267_297# 0.19351f
C25 VGND a_267_297# 0.00956f
C26 VPWR a_407_47# 0
C27 C B 0.02869f
C28 B VGND 0.01115f
C29 VPB VPWR 0.11562f
C30 C Y 0.11129f
C31 VGND Y 0.06455f
C32 C A 0.00391f
C33 VGND A 0.01618f
C34 VPWR D 0.0265f
C35 VPWR a_267_297# 0.23916f
C36 B VPWR 0.0122f
C37 a_49_47# a_407_47# 0.00437f
C38 VPWR Y 0.07249f
C39 C VGND 0.10333f
C40 a_131_297# D 0
C41 VPWR A 0.00949f
C42 VPB a_49_47# 0.00363f
C43 a_131_297# a_267_297# 0.00878f
C44 a_49_47# D 0.03419f
C45 a_49_47# a_267_297# 0
C46 a_131_297# Y 0.02823f
C47 B a_49_47# 0
C48 C VPWR 0.08552f
C49 VPWR VGND 0.00863f
C50 a_49_47# Y 0.03163f
C51 a_49_47# A 0.00455f
C52 D a_683_47# 0
C53 a_407_47# D 0.0034f
C54 a_683_47# a_267_297# 0.00361f
C55 C a_131_297# 0.00891f
C56 B a_407_47# 0
C57 VPB D 0.07781f
C58 VPB a_267_297# 0.01984f
C59 VPB B 0.03232f
C60 C a_49_47# 0.032f
C61 Y a_683_47# 0.00662f
C62 a_49_47# VGND 0.11466f
C63 VGND VNB 0.65313f
C64 VPWR VNB 0.42525f
C65 Y VNB 0.26455f
C66 VPB VNB 0.95915f
C67 a_683_47# VNB 0.22281f
C68 a_49_47# VNB 0.0327f
C69 a_267_297# VNB 0.1151f
.ends
