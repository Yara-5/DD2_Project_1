* NGSPICE file created from dd2_g5__maj4n_1.ext - technology: sky130A

.subckt dd2_g5__maj4n_1 A B C D VGND VNB VPB VPWR Y
X0 a_683_47# C Y VNB sky130_fd_pr__nfet_01v8 ad=0.17225 pd=1.18 as=0.17875 ps=1.2 w=0.65 l=0.15
X1 VGND D a_683_47# VNB sky130_fd_pr__nfet_01v8 ad=0.169 pd=1.82 as=0.17225 ps=1.18 w=0.65 l=0.15
X2 VPWR C a_267_297# VPB sky130_fd_pr__pfet_01v8_hvt ad=0.265 pd=1.53 as=0.275 ps=1.55 w=1 l=0.15
X3 a_267_297# D VPWR VPB sky130_fd_pr__pfet_01v8_hvt ad=0.26 pd=2.52 as=0.265 ps=1.53 w=1 l=0.15
X4 Y A a_267_297# VPB sky130_fd_pr__pfet_01v8_hvt ad=0.265 pd=1.53 as=0.275 ps=1.55 w=1 l=0.15
X5 VGND C a_49_47# VNB sky130_fd_pr__nfet_01v8 ad=0.17225 pd=1.18 as=0.169 ps=1.82 w=0.65 l=0.15
X6 a_267_297# B Y VPB sky130_fd_pr__pfet_01v8_hvt ad=0.275 pd=1.55 as=0.265 ps=1.53 w=1 l=0.15
X7 a_49_47# D VGND VNB sky130_fd_pr__nfet_01v8 ad=0.17875 pd=1.2 as=0.17225 ps=1.18 w=0.65 l=0.15
X8 Y B a_407_47# VNB sky130_fd_pr__nfet_01v8 ad=0.17875 pd=1.2 as=0.17225 ps=1.18 w=0.65 l=0.15
X9 a_131_297# C Y VPB sky130_fd_pr__pfet_01v8_hvt ad=0.265 pd=1.53 as=0.26 ps=2.52 w=1 l=0.15
X10 a_267_297# D a_131_297# VPB sky130_fd_pr__pfet_01v8_hvt ad=0.275 pd=1.55 as=0.265 ps=1.53 w=1 l=0.15
X11 a_407_47# A a_49_47# VNB sky130_fd_pr__nfet_01v8 ad=0.17225 pd=1.18 as=0.17875 ps=1.2 w=0.65 l=0.15
C0 a_49_47# A 0.00279f
C1 D a_683_47# 0.00591f
C2 a_407_47# D 0
C3 C a_131_297# 0.00471f
C4 a_131_297# VGND 0
C5 B a_407_47# 0
C6 VPB D 0.08008f
C7 VPB a_267_297# 0.02398f
C8 VPB B 0.03215f
C9 C a_49_47# 0.0642f
C10 Y a_683_47# 0.00172f
C11 a_49_47# VGND 0.08482f
C12 a_407_47# Y 0.01474f
C13 D a_267_297# 0.11113f
C14 B D 0.03119f
C15 VPB Y 0.02405f
C16 a_131_297# VPWR 0.01735f
C17 B a_267_297# 0.02246f
C18 VPB A 0.03225f
C19 D Y 0.07843f
C20 a_49_47# VPWR 0.00126f
C21 Y a_267_297# 0.12975f
C22 C a_683_47# 0.00702f
C23 VGND a_683_47# 0.0177f
C24 B Y 0.04245f
C25 D A 0.04209f
C26 C a_407_47# 0.0059f
C27 VGND a_407_47# 0.01199f
C28 A a_267_297# 0.01515f
C29 B A 0.01429f
C30 VPB C 0.06876f
C31 VPB VGND 0.01313f
C32 Y A 0.04038f
C33 a_49_47# a_131_297# 0
C34 C D 0.2037f
C35 VGND D 0.04177f
C36 C a_267_297# 0.01734f
C37 VPWR a_683_47# 0.00212f
C38 VGND a_267_297# 0.00659f
C39 VPWR a_407_47# 0
C40 C B 0.02187f
C41 B VGND 0.00903f
C42 VPB VPWR 0.12249f
C43 C Y 0.10279f
C44 VGND Y 0.04758f
C45 C A 0.00672f
C46 VGND A 0.01415f
C47 VPWR D 0.05072f
C48 VPWR a_267_297# 0.18568f
C49 B VPWR 0.00897f
C50 a_49_47# a_407_47# 0.002f
C51 VPWR Y 0.07077f
C52 C VGND 0.12009f
C53 a_131_297# D 0
C54 VPWR A 0.0069f
C55 VPB a_49_47# 0.00104f
C56 a_131_297# a_267_297# 0.00712f
C57 a_49_47# D 0.03022f
C58 a_131_297# Y 0.02761f
C59 B a_49_47# 0
C60 C VPWR 0.04059f
C61 VPWR VGND 0.02307f
C62 a_49_47# Y 0.01601f
C63 VGND VNB 0.65296f
C64 VPWR VNB 0.43356f
C65 Y VNB 0.23178f
C66 VPB VNB 0.95915f
C67 a_683_47# VNB 0.21077f
C68 a_49_47# VNB 0.01954f
C69 a_267_297# VNB 0.09439f
.ends
