* NGSPICE file created from dd2_g5__nand3_stack_1.ext - technology: sky130A

.subckt dd2_g5__nand3_stack_1 A B C VGND VNB VPB VPWR Y
X0 VGND.t2 C.t1 a_139_47.t1 VNB.t1 sky130_fd_pr__nfet_01v8 ad=0.08775 pd=0.92 as=0.08775 ps=0.92 w=0.65 l=0.15
X1 a_391_47.t5 B.t2 a_139_47.t3 VNB.t6 sky130_fd_pr__nfet_01v8 ad=0.08775 pd=0.92 as=0.08775 ps=0.92 w=0.65 l=0.15
X2 a_139_47.t0 C.t2 VGND.t0 VNB.t0 sky130_fd_pr__nfet_01v8 ad=0.08775 pd=0.92 as=0.169 ps=1.82 w=0.65 l=0.15
X3 VPWR.t0 A.t3 Y.t2 VPB.t1 sky130_fd_pr__pfet_01v8_hvt ad=0.26 pd=2.52 as=0.135 ps=1.27 w=1 l=0.15
X4 a_139_47.t2 C.t0 VGND.t1 VNB.t2 sky130_fd_pr__nfet_01v8 ad=0.08775 pd=0.92 as=0.08775 ps=0.92 w=0.65 l=0.15
X5 a_139_47.t4 B.t1 a_391_47.t4 VNB.t7 sky130_fd_pr__nfet_01v8 ad=0.08775 pd=0.92 as=0.08775 ps=0.92 w=0.65 l=0.15
X6 Y.t0 A.t2 a_391_47.t0 VNB.t3 sky130_fd_pr__nfet_01v8 ad=0.08775 pd=0.92 as=0.08775 ps=0.92 w=0.65 l=0.15
X7 Y.t4 B.t3 VPWR.t1 VPB.t2 sky130_fd_pr__pfet_01v8_hvt ad=0.135 pd=1.27 as=0.555 ps=2.11 w=1 l=0.15
X8 Y.t1 A.t0 a_391_47.t2 VNB.t5 sky130_fd_pr__nfet_01v8 ad=0.169 pd=1.82 as=0.08775 ps=0.92 w=0.65 l=0.15
X9 a_391_47.t3 B.t0 a_139_47.t5 VNB.t8 sky130_fd_pr__nfet_01v8 ad=0.08775 pd=0.92 as=0.08775 ps=0.92 w=0.65 l=0.15
X10 a_391_47.t1 A.t1 Y.t3 VNB.t4 sky130_fd_pr__nfet_01v8 ad=0.08775 pd=0.92 as=0.08775 ps=0.92 w=0.65 l=0.15
X11 VPWR.t2 C.t3 Y.t5 VPB.t0 sky130_fd_pr__pfet_01v8_hvt ad=0.555 pd=2.11 as=0.26 ps=2.52 w=1 l=0.15
R0 VGND.n2 VGND.n1 204.094
R1 VGND.n0 VGND.t0 152.016
R2 VGND.n1 VGND.t2 24.9236
R3 VGND.n1 VGND.t1 24.9236
R4 VGND.n2 VGND.n0 14.7075
R5 VGND.n4 VGND.n3 9.3005
R6 VGND VGND.n4 6.77697
R7 VGND.n0 VGND 3.10353
R8 VGND.n3 VGND.n2 1.48196
R9 VGND.n4 VGND.n0 1.12991
R10 VGND.n3 VGND 0.0239375
R11 VPWR.n4 VPWR.n2 607.212
R12 VPWR.n3 VPWR.t0 358.293
R13 VPWR.n2 VPWR.t1 192.076
R14 VPWR.n4 VPWR.n3 37.6306
R15 VPWR.n10 VPWR.n0 34.6358
R16 VPWR.n6 VPWR.n0 34.6358
R17 VPWR.n6 VPWR.n5 34.6358
R18 VPWR.n2 VPWR.t2 26.5955
R19 VPWR.n10 VPWR.n9 9.3005
R20 VPWR.n8 VPWR.n0 9.3005
R21 VPWR.n7 VPWR.n6 9.3005
R22 VPWR.n5 VPWR.n1 9.3005
R23 VPWR VPWR.n10 6.77697
R24 VPWR.n5 VPWR.n4 4.51815
R25 VPWR.n3 VPWR.n1 0.235347
R26 VPWR.n9 VPWR.n8 0.120292
R27 VPWR.n8 VPWR.n7 0.120292
R28 VPWR.n7 VPWR.n1 0.120292
R29 VPWR.n9 VPWR 0.0239375
R30 Y.n1 Y.t5 330.418
R31 Y.n2 Y.t1 312.305
R32 Y.n1 Y.n0 202.178
R33 Y.n4 Y.n3 185
R34 Y.n2 Y.n1 81.9114
R35 Y.n0 Y.t4 26.5955
R36 Y.n0 Y.t2 26.5955
R37 Y.n3 Y.t0 24.9236
R38 Y.n3 Y.t3 24.9236
R39 Y.n4 Y.n2 9.78874
R40 Y Y.n4 6.02403
R41 A.n1 A.t3 212.081
R42 A.n0 A.t0 201.125
R43 A A.n1 155.103
R44 A.n1 A.t2 139.78
R45 A.n0 A.t1 139.78
R46 A.n1 A.n0 61.346
R47 B.n0 B.t3 212.081
R48 B.n1 B.t2 201.125
R49 B B.n2 155.103
R50 B.n0 B.t0 139.78
R51 B.n1 B.t1 139.78
R52 B.n2 B.n1 52.5823
R53 B.n2 B.n0 8.76414
R54 C.n1 C.t3 212.081
R55 C.n0 C.t2 201.125
R56 C C.n1 155.103
R57 C.n1 C.t0 139.78
R58 C.n0 C.t1 139.78
R59 C.n1 C.n0 61.346
R60 VPB VPB.t0 781.308
R61 VPB.t0 VPB.t2 745.794
R62 VPB.t2 VPB.t1 248.599
R63 VNB VNB.t0 1366.99
R64 VNB.t4 VNB.t5 1196.12
R65 VNB.t3 VNB.t4 1196.12
R66 VNB.t8 VNB.t3 1196.12
R67 VNB.t7 VNB.t8 1196.12
R68 VNB.t6 VNB.t7 1196.12
R69 VNB.t2 VNB.t6 1196.12
R70 VNB.t1 VNB.t2 1196.12
R71 VNB.t0 VNB.t1 1196.12
R72 a_391_47.n2 a_391_47.n0 247.892
R73 a_391_47.n3 a_391_47.n2 246.868
R74 a_391_47.n2 a_391_47.n1 185
R75 a_391_47.n1 a_391_47.t0 24.9236
R76 a_391_47.n1 a_391_47.t3 24.9236
R77 a_391_47.n0 a_391_47.t4 24.9236
R78 a_391_47.n0 a_391_47.t5 24.9236
R79 a_391_47.t2 a_391_47.n3 24.9236
R80 a_391_47.n3 a_391_47.t1 24.9236
R81 a_139_47.n2 a_139_47.n0 248.248
R82 a_139_47.n2 a_139_47.n1 248.248
R83 a_139_47.n3 a_139_47.n2 185
R84 a_139_47.n1 a_139_47.t1 24.9236
R85 a_139_47.n1 a_139_47.t0 24.9236
R86 a_139_47.n0 a_139_47.t5 24.9236
R87 a_139_47.n0 a_139_47.t4 24.9236
R88 a_139_47.n3 a_139_47.t3 24.9236
R89 a_139_47.t2 a_139_47.n3 24.9236
C0 VGND A 0.02715f
C1 A VPB 0.0699f
C2 Y A 0.09734f
C3 B VGND 0.03007f
C4 B VPB 0.06574f
C5 B Y 0.04176f
C6 VPWR C 0.02441f
C7 VGND VPB 0.03406f
C8 Y VGND 0.03184f
C9 VPWR A 0.02589f
C10 Y VPB 0.0566f
C11 B VPWR 0.0191f
C12 B C 0.03256f
C13 B A 0.03922f
C14 VPWR VGND 0.05661f
C15 C VGND 0.05563f
C16 VPWR VPB 0.19124f
C17 VPWR Y 0.20147f
C18 C VPB 0.07668f
C19 Y C 0.03118f
C20 VGND VNB 0.57782f
C21 VPWR VNB 0.46088f
C22 Y VNB 0.07789f
C23 A VNB 0.19654f
C24 B VNB 0.16898f
C25 C VNB 0.20776f
C26 VPB VNB 1.0593f
C27 a_139_47.t3 VNB 0.03209f
C28 a_139_47.t5 VNB 0.02654f
C29 a_139_47.t4 VNB 0.02654f
C30 a_139_47.n0 VNB 0.03106f
C31 a_139_47.t1 VNB 0.02525f
C32 a_139_47.t0 VNB 0.0303f
C33 a_139_47.n1 VNB 0.03201f
C34 a_139_47.n2 VNB 0.08272f
C35 a_139_47.n3 VNB 0.0241f
C36 a_139_47.t2 VNB 0.02525f
C37 a_391_47.t1 VNB 0.02749f
C38 a_391_47.t4 VNB 0.02778f
C39 a_391_47.t5 VNB 0.03332f
C40 a_391_47.n0 VNB 0.0342f
C41 a_391_47.t0 VNB 0.02749f
C42 a_391_47.t3 VNB 0.02778f
C43 a_391_47.n1 VNB 0.02658f
C44 a_391_47.n2 VNB 0.08966f
C45 a_391_47.n3 VNB 0.03432f
C46 a_391_47.t2 VNB 0.03292f
C47 VPB.t1 VNB 0.18817f
C48 VPB.t2 VNB 0.08498f
C49 VPB.t0 VNB 0.1305f
C50 C.n0 VNB 0.06783f
C51 C.n1 VNB 0.05149f
C52 B.n0 VNB 0.03354f
C53 B.n1 VNB 0.07162f
C54 B.n2 VNB 0.02014f
C55 A.n0 VNB 0.07297f
C56 A.n1 VNB 0.05539f
C57 Y.t5 VNB 0.11446f
C58 Y.t2 VNB 0.0376f
C59 Y.t4 VNB 0.03802f
C60 Y.n0 VNB 0.03728f
C61 Y.n1 VNB 0.20023f
C62 Y.t1 VNB 0.06366f
C63 Y.n2 VNB 0.06914f
C64 Y.t3 VNB 0.02547f
C65 Y.t0 VNB 0.02547f
C66 Y.n3 VNB 0.02254f
C67 Y.n4 VNB 0.00458f
C68 VPWR.n0 VNB 0.00906f
C69 VPWR.n1 VNB 0.09452f
C70 VPWR.t1 VNB 0.07716f
C71 VPWR.t2 VNB 0.02666f
C72 VPWR.n2 VNB 0.06452f
C73 VPWR.t0 VNB 0.05065f
C74 VPWR.n3 VNB 0.15177f
C75 VPWR.n4 VNB 0.0154f
C76 VPWR.n5 VNB 0.00512f
C77 VPWR.n6 VNB 0.00906f
C78 VPWR.n7 VNB 0.02558f
C79 VPWR.n8 VNB 0.02558f
C80 VPWR.n9 VNB 0.01529f
C81 VPWR.n10 VNB 0.00542f
C82 VGND.t0 VNB 0.0373f
C83 VGND.n0 VNB 0.03401f
C84 VGND.t1 VNB 0.01854f
C85 VGND.t2 VNB 0.01854f
C86 VGND.n1 VNB 0.01228f
C87 VGND.n2 VNB 0.06317f
C88 VGND.n3 VNB 0.28834f
C89 VGND.n4 VNB 0.00109f
.ends
