* NGSPICE file created from dd2_g5__maj3_opt_1.ext - technology: sky130A

.subckt dd2_g5__maj3_opt_1 A B C VGND VNB VPB VPWR Y
X0 a_223_47# A a_141_47# VNB sky130_fd_pr__nfet_01v8 ad=0.17225 pd=1.18 as=0.169 ps=1.82 w=0.65 l=0.15
X1 a_359_47# B a_223_47# VNB sky130_fd_pr__nfet_01v8 ad=0.17875 pd=1.2 as=0.17225 ps=1.18 w=0.65 l=0.15
X2 VGND A a_141_47# VNB sky130_fd_pr__nfet_01v8 ad=0.09425 pd=0.94 as=0.17225 ps=1.18 w=0.65 l=0.15
X3 VPWR B a_635_343# VPB sky130_fd_pr__pfet_01v8_hvt ad=0.2002 pd=2.06 as=0.11165 ps=1.06 w=0.77 l=0.15
X4 Y a_359_47# VGND VNB sky130_fd_pr__nfet_01v8 ad=0.169 pd=1.82 as=0.169 ps=1.82 w=0.65 l=0.15
X5 a_141_47# C a_359_47# VNB sky130_fd_pr__nfet_01v8 ad=0.17225 pd=1.18 as=0.17875 ps=1.2 w=0.65 l=0.15
X6 a_359_47# C a_141_343# VPB sky130_fd_pr__pfet_01v8_hvt ad=0.20405 pd=1.3 as=0.21175 ps=1.32 w=0.77 l=0.15
X7 Y a_359_47# VPWR VPB sky130_fd_pr__pfet_01v8_hvt ad=0.26 pd=2.52 as=0.26 ps=2.52 w=1 l=0.15
X8 VPWR A a_141_343# VPB sky130_fd_pr__pfet_01v8_hvt ad=0.20405 pd=1.3 as=0.2002 ps=2.06 w=0.77 l=0.15
X9 a_635_343# A a_359_47# VPB sky130_fd_pr__pfet_01v8_hvt ad=0.11165 pd=1.06 as=0.20405 ps=1.3 w=0.77 l=0.15
X10 a_141_47# B VGND VNB sky130_fd_pr__nfet_01v8 ad=0.169 pd=1.82 as=0.09425 ps=0.94 w=0.65 l=0.15
X11 a_141_343# B VPWR VPB sky130_fd_pr__pfet_01v8_hvt ad=0.21175 pd=1.32 as=0.20405 ps=1.3 w=0.77 l=0.15
C0 VPB VPWR 0.18801f
C1 a_635_343# a_359_47# 0.01134f
C2 VPWR a_141_47# 0.17475f
C3 A VGND 0.025f
C4 a_141_343# a_223_47# 0.00369f
C5 a_141_343# C 0.00536f
C6 a_141_47# a_635_343# 0.00545f
C7 a_141_343# B 0.02182f
C8 A a_359_47# 0.21489f
C9 VGND a_141_343# 0.00405f
C10 Y a_223_47# 0
C11 VPWR a_635_343# 0.00934f
C12 B a_223_47# 0
C13 VGND a_223_47# 0.01273f
C14 Y C 0
C15 B C 0.04114f
C16 VPB A 0.11848f
C17 A a_141_47# 0.06677f
C18 VGND C 0.01372f
C19 Y B 0.00162f
C20 a_359_47# a_141_343# 0.06725f
C21 VGND Y 0.02363f
C22 A VPWR 0.02384f
C23 VGND B 0.08976f
C24 a_359_47# a_223_47# 0.0167f
C25 VPB a_141_343# 0.02896f
C26 a_359_47# C 0.01428f
C27 a_141_47# a_141_343# 0.06573f
C28 A a_635_343# 0
C29 Y a_359_47# 0.05456f
C30 a_359_47# B 0.11368f
C31 a_141_47# a_223_47# 0.00819f
C32 VPWR a_141_343# 0.08598f
C33 VGND a_359_47# 0.10616f
C34 VPB C 0.04998f
C35 a_141_47# C 0.00899f
C36 VPB Y 0.0221f
C37 VPB B 0.11301f
C38 a_141_47# Y 0.01861f
C39 a_141_47# B 0.1464f
C40 VPWR C 0.01249f
C41 VPB VGND 0.0197f
C42 VGND a_141_47# 0.16606f
C43 VPWR Y 0.02236f
C44 VPWR B 0.02853f
C45 VGND VPWR 0.01899f
C46 VPB a_359_47# 0.0877f
C47 A a_141_343# 0.02806f
C48 a_141_47# a_359_47# 0.36118f
C49 a_635_343# Y 0
C50 a_635_343# B 0
C51 A a_223_47# 0
C52 VPWR a_359_47# 0.10263f
C53 VPB a_141_47# 0.05547f
C54 A C 0.03809f
C55 A Y 0
C56 A B 0.18031f
C57 VGND VNB 0.74267f
C58 Y VNB 0.18173f
C59 VPWR VNB 0.53034f
C60 VPB VNB 1.13634f
C61 a_223_47# VNB 0.17239f
C62 a_141_47# VNB 0.29001f
C63 a_141_343# VNB 0.02333f
.ends
