* NGSPICE file created from dd2_g5__nor2_stack_1.ext - technology: sky130A

.subckt dd2_g5__nor2_stack_1 A B VGND VNB VPB VPWR Y
X0 a_37_297.t1 B.t1 Y.t3 VPB.t1 sky130_fd_pr__pfet_01v8_hvt ad=0.26 pd=2.52 as=0.135 ps=1.27 w=1 l=0.15
X1 Y.t1 B.t2 a_37_297.t0 VPB.t0 sky130_fd_pr__pfet_01v8_hvt ad=0.135 pd=1.27 as=0.135 ps=1.27 w=1 l=0.15
X2 a_37_297.t3 A.t1 VPWR.t1 VPB.t3 sky130_fd_pr__pfet_01v8_hvt ad=0.135 pd=1.27 as=0.135 ps=1.27 w=1 l=0.15
X3 Y.t0 A.t0 VGND.t0 VNB.t1 sky130_fd_pr__nfet_01v8 ad=0.08775 pd=0.92 as=0.169 ps=1.82 w=0.65 l=0.15
X4 VPWR.t0 A.t2 a_37_297.t2 VPB.t2 sky130_fd_pr__pfet_01v8_hvt ad=0.135 pd=1.27 as=0.26 ps=2.52 w=1 l=0.15
X5 VGND.t1 B.t0 Y.t2 VNB.t0 sky130_fd_pr__nfet_01v8 ad=0.169 pd=1.82 as=0.08775 ps=0.92 w=0.65 l=0.15
R0 VGND.n1 VGND.t1 288.19
R1 VGND.n0 VGND.t0 149.762
R2 VGND.n3 VGND.n0 25.224
R3 VGND.n3 VGND.n2 9.3005
R4 VGND VGND.n3 6.77697
R5 VGND.n1 VGND.n0 6.32944
R6 VGND.n2 VGND.n1 0.65705
R7 VGND.n2 VGND 0.0239375
R8 Y.n2 Y.n0 683.226
R9 Y.n2 Y.n1 185
R10 Y.n0 Y.t3 26.5955
R11 Y.n0 Y.t1 26.5955
R12 Y.n1 Y.t2 24.9236
R13 Y.n1 Y.t0 24.9236
R14 Y.n2 Y 7.31479
R15 Y Y.n2 6.02403
R16 VPWR.n1 VPWR.n0 614.412
R17 VPWR.n0 VPWR.t1 26.5955
R18 VPWR.n0 VPWR.t0 26.5955
R19 VPWR VPWR.n1 13.1075
R20 VPWR.n1 VPWR 1.32092
R21 B.n0 B.t1 273.425
R22 B.n0 B.t2 212.081
R23 B B.n0 155.103
R24 B.n0 B.t0 139.78
R25 A.n1 A.t2 264.663
R26 A.n0 A.t1 212.081
R27 A A.n1 155.103
R28 A.n0 A.t0 139.78
R29 A.n1 A.n0 8.76414
R30 VPB.t0 VPB.t1 248.599
R31 VPB.t3 VPB.t0 248.599
R32 VPB.t2 VPB.t3 248.599
R33 VPB VPB.t2 224.923
R34 VNB VNB.t1 2278.32
R35 VNB.t1 VNB.t0 1196.12
R36 a_37_297.t1 a_37_297.n1 373.654
R37 a_37_297.n1 a_37_297.t2 279.711
R38 a_37_297.n1 a_37_297.n0 189.28
R39 a_37_297.n0 a_37_297.t0 26.5955
R40 a_37_297.n0 a_37_297.t3 26.5955
C0 B Y 0.06309f
C1 VPB VPWR 0.05987f
C2 VPB VGND 0.01027f
C3 VPB A 0.05541f
C4 VPB Y 0.01004f
C5 B VPB 0.0579f
C6 VGND VPWR 0.02536f
C7 A VPWR 0.03069f
C8 A VGND 0.03785f
C9 Y VPWR 0.00787f
C10 Y VGND 0.06134f
C11 B VPWR 0.01738f
C12 Y A 0.00443f
C13 B VGND 0.02181f
C14 B A 0.03922f
C15 VGND VNB 0.36517f
C16 Y VNB 0.06361f
C17 VPWR VNB 0.46857f
C18 B VNB 0.13847f
C19 A VNB 0.14336f
C20 VPB VNB 0.55789f
C21 a_37_297.t0 VNB 0.03428f
C22 a_37_297.t3 VNB 0.03302f
C23 a_37_297.n0 VNB 0.0253f
C24 a_37_297.t2 VNB 0.08353f
C25 a_37_297.n1 VNB 0.1559f
C26 a_37_297.t1 VNB 0.07942f
C27 VPB.t1 VNB 0.07382f
C28 VPB.t0 VNB 0.0337f
C29 VPB.t3 VNB 0.0337f
C30 VPB.t2 VNB 0.0321f
C31 A.n0 VNB 0.03303f
C32 A.n1 VNB 0.05012f
C33 B.n0 VNB 0.09255f
C34 VPWR.t1 VNB 0.03125f
C35 VPWR.t0 VNB 0.03501f
C36 VPWR.n0 VNB 0.02243f
C37 VPWR.n1 VNB 0.03874f
C38 Y.t3 VNB 0.04226f
C39 Y.t1 VNB 0.03742f
C40 Y.n0 VNB 0.03763f
C41 Y.t2 VNB 0.02542f
C42 Y.t0 VNB 0.02453f
C43 Y.n1 VNB 0.02053f
C44 Y.n2 VNB 0.07145f
C45 VGND.t0 VNB 0.02699f
C46 VGND.n0 VNB 0.02877f
C47 VGND.t1 VNB 0.02797f
C48 VGND.n1 VNB 0.04f
C49 VGND.n2 VNB 0.06788f
C50 VGND.n3 VNB 0.00287f
.ends
