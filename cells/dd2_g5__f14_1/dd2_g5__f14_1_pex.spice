* NGSPICE file created from dd2_g5__f14_1.ext - technology: sky130A

.subckt dd2_g5__f14_1 A B C D VGND VNB VPB VPWR Y
X0 Y.t1 B.t1 a_65_297.t2 VPB.t3 sky130_fd_pr__pfet_01v8_hvt ad=0.165 pd=1.33 as=0.165 ps=1.33 w=1 l=0.15
X1 VPWR.t1 A.t1 Y.t2 VPB.t2 sky130_fd_pr__pfet_01v8_hvt ad=0.26 pd=2.52 as=0.165 ps=1.33 w=1 l=0.15
X2 VGND.t1 D.t0 a_147_47.t0 VNB.t0 sky130_fd_pr__nfet_01v8 ad=0.10725 pd=0.98 as=0.08775 ps=0.92 w=0.65 l=0.15
X3 a_65_297.t0 D.t1 VPWR.t0 VPB.t0 sky130_fd_pr__pfet_01v8_hvt ad=0.165 pd=1.33 as=0.135 ps=1.27 w=1 l=0.15
X4 a_147_47.t1 C.t0 a_65_47.t0 VNB.t1 sky130_fd_pr__nfet_01v8 ad=0.08775 pd=0.92 as=0.169 ps=1.82 w=0.65 l=0.15
X5 VPWR.t2 C.t1 a_65_297.t1 VPB.t1 sky130_fd_pr__pfet_01v8_hvt ad=0.135 pd=1.27 as=0.26 ps=2.52 w=1 l=0.15
X6 Y.t0 A.t0 a_65_47.t1 VNB.t2 sky130_fd_pr__nfet_01v8 ad=0.169 pd=1.82 as=0.10725 ps=0.98 w=0.65 l=0.15
X7 a_65_47.t2 B.t0 VGND.t0 VNB.t3 sky130_fd_pr__nfet_01v8 ad=0.10725 pd=0.98 as=0.10725 ps=0.98 w=0.65 l=0.15
R0 VGND.n1 VGND.n0 205.18
R1 VGND.n0 VGND.t0 30.462
R2 VGND.n0 VGND.t1 30.462
R3 VGND VGND.n1 14.1779
R4 VGND.n1 VGND 0.248827
R5 Y.n1 Y.n0 395.654
R6 Y.t0 Y.n1 268.077
R7 Y Y.t0 265.829
R8 Y.n0 Y.t2 32.5055
R9 Y.n0 Y.t1 32.5055
R10 Y.n2 Y 2.90959
R11 Y.n2 Y.n1 2.86366
R12 Y Y.n2 2.52682
R13 VPWR.n2 VPWR.n1 607.212
R14 VPWR.n3 VPWR.t1 360.086
R15 VPWR.n6 VPWR.n0 34.6358
R16 VPWR.n3 VPWR.n2 28.5124
R17 VPWR.n1 VPWR.t2 26.5955
R18 VPWR.n1 VPWR.t0 26.5955
R19 VPWR.n2 VPWR.n0 13.5534
R20 VPWR.n6 VPWR.n5 9.3005
R21 VPWR.n4 VPWR.n0 9.3005
R22 VPWR VPWR.n6 6.77697
R23 VPWR.n4 VPWR.n3 0.318301
R24 VPWR.n5 VPWR.n4 0.120292
R25 VPWR.n5 VPWR 0.0239375
R26 A.n0 A.t1 241.536
R27 A.n0 A.t0 169.237
R28 A A.n0 155.103
R29 B.n0 B.t1 241.536
R30 B.n0 B.t0 169.237
R31 B B.n0 155.103
R32 D.n0 D.t1 241.536
R33 D.n0 D.t0 169.237
R34 D D.n0 155.103
R35 C.n0 C.t1 241.536
R36 C.n0 C.t0 169.237
R37 C C.n0 155.103
R38 VPB VPB.t1 307.788
R39 VPB.t3 VPB.t2 284.113
R40 VPB.t0 VPB.t3 284.113
R41 VPB.t1 VPB.t0 248.599
R42 VNB VNB.t1 1480.91
R43 VNB.t3 VNB.t2 1366.99
R44 VNB.t0 VNB.t3 1366.99
R45 VNB.t1 VNB.t0 1196.12
R46 a_147_47.t0 a_147_47.t1 49.8467
R47 a_65_47.t0 a_65_47.n0 405.911
R48 a_65_47.n0 a_65_47.t1 30.462
R49 a_65_47.n0 a_65_47.t2 30.462
R50 a_65_297.n0 a_65_297.t1 470.887
R51 a_65_297.n0 a_65_297.t2 32.5055
R52 a_65_297.t0 a_65_297.n0 32.5055
C0 VGND C 0.01239f
C1 B Y 0.00788f
C2 D VPB 0.02591f
C3 C Y 0
C4 VPWR D 0.01709f
C5 A VPB 0.03178f
C6 VPWR VPB 0.1012f
C7 VGND D 0.01574f
C8 VPWR A 0.02079f
C9 VGND VPB 0.01364f
C10 VGND A 0.01613f
C11 VGND VPWR 0.03114f
C12 B D 0.03636f
C13 D Y 0
C14 B VPB 0.02688f
C15 Y VPB 0.01695f
C16 B A 0.03636f
C17 A Y 0.05094f
C18 VPWR B 0.01802f
C19 D C 0.03922f
C20 VPWR Y 0.05297f
C21 VGND B 0.01607f
C22 C VPB 0.0308f
C23 VGND Y 0.0348f
C24 VPWR C 0.01542f
C25 VGND VNB 0.50514f
C26 Y VNB 0.09408f
C27 VPWR VNB 0.3229f
C28 A VNB 0.10113f
C29 B VNB 0.07668f
C30 D VNB 0.07719f
C31 C VNB 0.11149f
C32 VPB VNB 0.65458f
C33 a_65_297.t2 VNB 0.04241f
C34 a_65_297.t1 VNB 0.12606f
C35 a_65_297.n0 VNB 0.0959f
C36 a_65_297.t0 VNB 0.04418f
C37 a_65_47.t1 VNB 0.03211f
C38 a_65_47.t2 VNB 0.03332f
C39 a_65_47.n0 VNB 0.07246f
C40 a_65_47.t0 VNB 0.11986f
C41 a_147_47.t1 VNB 0.02599f
C42 a_147_47.t0 VNB 0.02996f
C43 VPB.t2 VNB 0.0971f
C44 VPB.t3 VNB 0.04053f
C45 VPB.t0 VNB 0.038f
C46 VPB.t1 VNB 0.03969f
C47 C.n0 VNB 0.0478f
C48 D.n0 VNB 0.05887f
C49 B.n0 VNB 0.05531f
C50 A.n0 VNB 0.05194f
C51 VPWR.n0 VNB 0.00781f
C52 VPWR.t0 VNB 0.03894f
C53 VPWR.t2 VNB 0.03344f
C54 VPWR.n1 VNB 0.01967f
C55 VPWR.n2 VNB 0.01941f
C56 VPWR.t1 VNB 0.06351f
C57 VPWR.n3 VNB 0.11078f
C58 VPWR.n4 VNB 0.10682f
C59 VPWR.n5 VNB 0.01896f
C60 VPWR.n6 VNB 0.00671f
C61 Y.t2 VNB 0.04321f
C62 Y.t1 VNB 0.04488f
C63 Y.n0 VNB 0.04642f
C64 Y.n1 VNB 0.07148f
C65 Y.t0 VNB 0.0469f
C66 Y.n2 VNB 0.00903f
C67 VGND.t0 VNB 0.02595f
C68 VGND.t1 VNB 0.02723f
C69 VGND.n0 VNB 0.01388f
C70 VGND.n1 VNB 0.06907f
.ends
