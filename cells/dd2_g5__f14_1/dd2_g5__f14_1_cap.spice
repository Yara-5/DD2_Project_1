* NGSPICE file created from dd2_g5__f14_1.ext - technology: sky130A

.subckt dd2_g5__f14_1 A B C D VGND VNB VPB VPWR Y
X0 Y B a_65_297# VPB sky130_fd_pr__pfet_01v8_hvt ad=0.165 pd=1.33 as=0.165 ps=1.33 w=1 l=0.15
X1 VPWR A Y VPB sky130_fd_pr__pfet_01v8_hvt ad=0.26 pd=2.52 as=0.165 ps=1.33 w=1 l=0.15
X2 VGND D a_147_47# VNB sky130_fd_pr__nfet_01v8 ad=0.10725 pd=0.98 as=0.08775 ps=0.92 w=0.65 l=0.15
X3 a_65_297# D VPWR VPB sky130_fd_pr__pfet_01v8_hvt ad=0.165 pd=1.33 as=0.135 ps=1.27 w=1 l=0.15
X4 a_147_47# C a_65_47# VNB sky130_fd_pr__nfet_01v8 ad=0.08775 pd=0.92 as=0.169 ps=1.82 w=0.65 l=0.15
X5 VPWR C a_65_297# VPB sky130_fd_pr__pfet_01v8_hvt ad=0.135 pd=1.27 as=0.26 ps=2.52 w=1 l=0.15
X6 Y A a_65_47# VNB sky130_fd_pr__nfet_01v8 ad=0.169 pd=1.82 as=0.10725 ps=0.98 w=0.65 l=0.15
X7 a_65_47# B VGND VNB sky130_fd_pr__nfet_01v8 ad=0.10725 pd=0.98 as=0.10725 ps=0.98 w=0.65 l=0.15
C0 VGND C 0.01239f
C1 VGND a_65_297# 0.00491f
C2 VPB VPWR 0.1012f
C3 C a_65_297# 0.0276f
C4 VGND Y 0.0348f
C5 C Y 0
C6 B VGND 0.01607f
C7 VGND a_147_47# 0.00644f
C8 a_65_297# Y 0.02665f
C9 B a_65_297# 0.00989f
C10 a_147_47# a_65_297# 0
C11 B Y 0.00788f
C12 a_147_47# Y 0
C13 a_65_47# D 0.01915f
C14 VPB a_65_47# 0.00308f
C15 A VPB 0.03178f
C16 VGND VPWR 0.03114f
C17 VPWR C 0.01542f
C18 VPWR a_65_297# 0.10295f
C19 VPWR Y 0.05297f
C20 B VPWR 0.01802f
C21 a_147_47# VPWR 0
C22 VGND a_65_47# 0.09101f
C23 A VGND 0.01613f
C24 a_65_47# C 0.02106f
C25 a_65_47# a_65_297# 0.01293f
C26 A a_65_297# 0.00103f
C27 a_65_47# Y 0.02013f
C28 A Y 0.05094f
C29 B a_65_47# 0.01841f
C30 a_65_47# a_147_47# 0.00967f
C31 B A 0.03636f
C32 VPB D 0.02591f
C33 a_65_47# VPWR 0.00415f
C34 A VPWR 0.02079f
C35 VGND D 0.01574f
C36 C D 0.03922f
C37 D a_65_297# 0.02674f
C38 VPB VGND 0.01364f
C39 D Y 0
C40 VPB C 0.0308f
C41 B D 0.03636f
C42 a_147_47# D 0
C43 VPB a_65_297# 0.0149f
C44 VPB Y 0.01695f
C45 B VPB 0.02688f
C46 A a_65_47# 0.00249f
C47 VPWR D 0.01709f
C48 VGND VNB 0.38128f
C49 Y VNB 0.1412f
C50 VPWR VNB 0.34646f
C51 VPB VNB 0.60476f
C52 a_147_47# VNB 0.07461f
C53 a_65_47# VNB 0.0777f
C54 a_65_297# VNB 0.0615f
.ends
