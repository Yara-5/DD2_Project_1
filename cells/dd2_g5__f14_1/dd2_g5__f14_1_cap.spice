* NGSPICE file created from dd2_g5__f14_1.ext - technology: sky130A

.subckt dd2_g5__f14_1 A B C D VGND VNB VPB VPWR Y
X0 Y B a_65_297# VPB sky130_fd_pr__pfet_01v8_hvt ad=0.165 pd=1.33 as=0.165 ps=1.33 w=1 l=0.15
X1 VPWR A Y VPB sky130_fd_pr__pfet_01v8_hvt ad=0.26 pd=2.52 as=0.165 ps=1.33 w=1 l=0.15
X2 VGND D a_147_47# VNB sky130_fd_pr__nfet_01v8 ad=0.10725 pd=0.98 as=0.08775 ps=0.92 w=0.65 l=0.15
X3 a_65_297# D VPWR VPB sky130_fd_pr__pfet_01v8_hvt ad=0.165 pd=1.33 as=0.135 ps=1.27 w=1 l=0.15
X4 a_147_47# C a_65_47# VNB sky130_fd_pr__nfet_01v8 ad=0.08775 pd=0.92 as=0.169 ps=1.82 w=0.65 l=0.15
X5 VPWR C a_65_297# VPB sky130_fd_pr__pfet_01v8_hvt ad=0.135 pd=1.27 as=0.26 ps=2.52 w=1 l=0.15
X6 Y A a_65_47# VNB sky130_fd_pr__nfet_01v8 ad=0.169 pd=1.82 as=0.10725 ps=0.98 w=0.65 l=0.15
X7 a_65_47# B VGND VNB sky130_fd_pr__nfet_01v8 ad=0.10725 pd=0.98 as=0.10725 ps=0.98 w=0.65 l=0.15
C0 A VGND 0.01796f
C1 a_65_47# C 0.01859f
C2 a_65_47# a_65_297# 0.01141f
C3 a_65_47# Y 0.01631f
C4 A Y 0.04248f
C5 B a_65_47# 0.01831f
C6 a_65_47# a_147_47# 0.00823f
C7 B A 0.03636f
C8 VPB D 0.02591f
C9 a_65_47# VPWR 0.00481f
C10 A VPWR 0.01827f
C11 VGND D 0.01574f
C12 C D 0.03922f
C13 D a_65_297# 0.01905f
C14 VPB VGND 0.01442f
C15 D Y 0
C16 VPB C 0.0308f
C17 B D 0.03636f
C18 a_147_47# D 0
C19 VPB a_65_297# 0.00795f
C20 VPB Y 0.01527f
C21 B VPB 0.0269f
C22 A a_65_47# 0.00299f
C23 VPWR D 0.01749f
C24 VGND C 0.01326f
C25 VGND a_65_297# 0.00573f
C26 VPB VPWR 0.10437f
C27 C a_65_297# 0.01995f
C28 VGND Y 0.02283f
C29 C Y 0
C30 B VGND 0.01607f
C31 VGND a_147_47# 0.00644f
C32 a_65_297# Y 0.01092f
C33 B a_65_297# 0.00303f
C34 a_147_47# a_65_297# 0
C35 B Y 0.00412f
C36 a_147_47# Y 0
C37 a_65_47# D 0.01812f
C38 VPB a_65_47# 0.00285f
C39 A VPB 0.03178f
C40 VGND VPWR 0.03175f
C41 VPWR C 0.01692f
C42 VPWR a_65_297# 0.05532f
C43 VPWR Y 0.03893f
C44 B VPWR 0.0191f
C45 a_147_47# VPWR 0
C46 VGND a_65_47# 0.07845f
C47 VGND VNB 0.39032f
C48 Y VNB 0.13304f
C49 VPWR VNB 0.34278f
C50 VPB VNB 0.60476f
C51 a_147_47# VNB 0.07461f
C52 a_65_47# VNB 0.06839f
C53 a_65_297# VNB 0.04207f
.ends
