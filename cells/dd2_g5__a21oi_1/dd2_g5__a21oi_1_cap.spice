* NGSPICE file created from dd2_g5__a21oi_1.ext - technology: sky130A

.subckt dd2_g5__a21oi_1 A1 A2 B1 VGND VNB VPB VPWR Y
X0 a_111_297# A2 VPWR VPB sky130_fd_pr__pfet_01v8_hvt ad=0.26 pd=2.52 as=0.135 ps=1.27 w=1 l=0.15
X1 VPWR A1 a_111_297# VPB sky130_fd_pr__pfet_01v8_hvt ad=0.135 pd=1.27 as=0.155 ps=1.31 w=1 l=0.15
X2 a_111_297# B1 Y VPB sky130_fd_pr__pfet_01v8_hvt ad=0.155 pd=1.31 as=0.26 ps=2.52 w=1 l=0.15
X3 Y B1 VGND VNB sky130_fd_pr__nfet_01v8 ad=0.10075 pd=0.96 as=0.169 ps=1.82 w=0.65 l=0.15
X4 a_203_47# A1 Y VNB sky130_fd_pr__nfet_01v8 ad=0.08775 pd=0.92 as=0.10075 ps=0.96 w=0.65 l=0.15
X5 VGND A2 a_203_47# VNB sky130_fd_pr__nfet_01v8 ad=0.169 pd=1.82 as=0.08775 ps=0.92 w=0.65 l=0.15
C0 a_111_297# B1 0.00591f
C1 A2 a_111_297# 0.02516f
C2 VPWR a_203_47# 0.00122f
C3 Y VGND 0.03304f
C4 Y B1 0.05418f
C5 VPWR VPB 0.05077f
C6 a_111_297# a_203_47# 0.0018f
C7 Y A2 0.00274f
C8 VPWR A1 0.01558f
C9 a_111_297# VPB 0.01322f
C10 VGND B1 0.02625f
C11 a_111_297# A1 0.0211f
C12 VGND A2 0.02782f
C13 Y a_203_47# 0.0017f
C14 Y VPB 0.01405f
C15 VGND a_203_47# 0.01295f
C16 Y A1 0.02431f
C17 VGND VPB 0.00796f
C18 B1 VPB 0.0381f
C19 a_111_297# VPWR 0.102f
C20 VGND A1 0.02084f
C21 A2 VPB 0.02938f
C22 B1 A1 0.02424f
C23 A2 A1 0.03922f
C24 Y VPWR 0.02261f
C25 Y a_111_297# 0.03068f
C26 VGND VPWR 0.02172f
C27 A1 a_203_47# 0
C28 VPWR B1 0.01383f
C29 A1 VPB 0.02563f
C30 A2 VPWR 0.01465f
C31 VGND a_111_297# 0.01027f
C32 VGND VNB 0.29286f
C33 VPWR VNB 0.28766f
C34 Y VNB 0.11138f
C35 VPB VNB 0.42757f
C36 a_111_297# VNB 0.1721f
.ends
