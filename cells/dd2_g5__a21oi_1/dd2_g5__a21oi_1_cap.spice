* NGSPICE file created from dd2_g5__a21oi_1.ext - technology: sky130A

.subckt dd2_g5__a21oi_1 A1 A2 B1 VGND VNB VPB VPWR Y
X0 a_255_47# A1 Y VNB sky130_fd_pr__nfet_01v8 ad=0.08775 pd=0.92 as=0.10725 ps=0.98 w=0.65 l=0.15
X1 a_159_297# A2 VPWR VPB sky130_fd_pr__pfet_01v8_hvt ad=0.26 pd=2.52 as=0.135 ps=1.27 w=1 l=0.15
X2 a_159_297# B1 Y VPB sky130_fd_pr__pfet_01v8_hvt ad=0.165 pd=1.33 as=0.26 ps=2.52 w=1 l=0.15
X3 VPWR A1 a_159_297# VPB sky130_fd_pr__pfet_01v8_hvt ad=0.135 pd=1.27 as=0.165 ps=1.33 w=1 l=0.15
X4 Y B1 VGND VNB sky130_fd_pr__nfet_01v8 ad=0.10725 pd=0.98 as=0.169 ps=1.82 w=0.65 l=0.15
X5 VGND A2 a_255_47# VNB sky130_fd_pr__nfet_01v8 ad=0.169 pd=1.82 as=0.08775 ps=0.92 w=0.65 l=0.15
C0 A2 VPWR 0.01709f
C1 VGND a_159_297# 0.01148f
C2 a_159_297# B1 0.00303f
C3 A2 a_159_297# 0.02032f
C4 VPWR a_255_47# 0.00122f
C5 Y VGND 0.05178f
C6 Y B1 0.04059f
C7 VPWR VPB 0.08688f
C8 a_159_297# a_255_47# 0.00238f
C9 Y A2 0.00198f
C10 VPWR A1 0.01689f
C11 a_159_297# VPB 0.00797f
C12 VGND B1 0.01659f
C13 a_159_297# A1 0.01905f
C14 VGND A2 0.02276f
C15 Y a_255_47# 0.00262f
C16 Y VPB 0.01428f
C17 VGND a_255_47# 0.01029f
C18 Y A1 0.00408f
C19 VGND VPB 0.01532f
C20 B1 VPB 0.03184f
C21 a_159_297# VPWR 0.05361f
C22 VGND A1 0.01962f
C23 A2 VPB 0.03093f
C24 B1 A1 0.03636f
C25 A2 A1 0.03922f
C26 Y VPWR 0.01866f
C27 Y a_159_297# 0.01578f
C28 VGND VPWR 0.02754f
C29 A1 a_255_47# 0
C30 VPWR B1 0.01757f
C31 A1 VPB 0.02591f
C32 VGND VNB 0.33083f
C33 VPWR VNB 0.30813f
C34 Y VNB 0.14147f
C35 VPB VNB 0.51617f
C36 a_255_47# VNB 0.02773f
C37 a_159_297# VNB 0.10216f
.ends
