* dd2_g5__a21oi_1: Y = !B1 & (!A1 | !A2)
* Generated by synthesize.py; stages in signal order:
*   Y = !(B1 | (A1 & A2))
.subckt dd2_g5__a21oi_1 A1 A2 B1 VGND VNB VPB VPWR Y
XN1 Y B1 VGND VNB sky130_fd_pr__nfet_01v8 w=0.65 l=0.15
XN2 Y A1 Y_d1 VNB sky130_fd_pr__nfet_01v8 w=0.65 l=0.15
XN3 Y_d1 A2 VGND VNB sky130_fd_pr__nfet_01v8 w=0.65 l=0.15
XP1 Y_u1 B1 VPWR VPB sky130_fd_pr__pfet_01v8_hvt w=1 l=0.15
XP2 Y A1 Y_u1 VPB sky130_fd_pr__pfet_01v8_hvt w=1 l=0.15
XP3 Y A2 Y_u1 VPB sky130_fd_pr__pfet_01v8_hvt w=1 l=0.15
.ends dd2_g5__a21oi_1
