* NGSPICE file created from dd2_g5__a21oi_1.ext - technology: sky130A

.subckt dd2_g5__a21oi_1 A1 A2 B1 VGND VNB VPB VPWR Y
X0 a_111_297.t1 A2.t1 VPWR.t0 VPB.t1 sky130_fd_pr__pfet_01v8_hvt ad=0.26 pd=2.52 as=0.135 ps=1.27 w=1 l=0.15
X1 VPWR.t1 A1.t1 a_111_297.t2 VPB.t2 sky130_fd_pr__pfet_01v8_hvt ad=0.135 pd=1.27 as=0.155 ps=1.31 w=1 l=0.15
X2 a_111_297.t0 B1.t1 Y.t0 VPB.t0 sky130_fd_pr__pfet_01v8_hvt ad=0.155 pd=1.31 as=0.26 ps=2.52 w=1 l=0.15
X3 Y.t2 B1.t0 VGND.t1 VNB.t0 sky130_fd_pr__nfet_01v8 ad=0.10075 pd=0.96 as=0.169 ps=1.82 w=0.65 l=0.15
X4 a_203_47.t1 A1.t0 Y.t1 VNB.t2 sky130_fd_pr__nfet_01v8 ad=0.08775 pd=0.92 as=0.10075 ps=0.96 w=0.65 l=0.15
X5 VGND.t0 A2.t0 a_203_47.t0 VNB.t1 sky130_fd_pr__nfet_01v8 ad=0.169 pd=1.82 as=0.08775 ps=0.92 w=0.65 l=0.15
R0 VGND.n1 VGND.t1 282.817
R1 VGND.n0 VGND.t0 156.815
R2 VGND.n1 VGND.n0 6.76909
R3 VGND VGND.n1 3.10353
R4 VGND.n0 VGND 0.168929
R5 VPWR.n1 VPWR.n0 613.638
R6 VPWR.n0 VPWR.t0 26.5955
R7 VPWR.n0 VPWR.t1 26.5955
R8 VPWR VPWR.n1 14.1301
R9 VPWR.n1 VPWR 0.298348
R10 Y.n1 Y.t0 398.339
R11 Y.n1 Y.n0 185
R12 Y.n0 Y.t1 28.6159
R13 Y.n0 Y.t2 28.6159
R14 Y Y.n1 2.76807
R15 A2.n0 A2.t1 241.536
R16 A2.n0 A2.t0 169.237
R17 A2 A2.n0 155.103
R18 A1.n0 A1.t1 241.536
R19 A1.n0 A1.t0 169.237
R20 A1 A1.n0 155.103
R21 B1.n0 B1.t1 230.155
R22 B1.n0 B1.t0 157.856
R23 B1 B1.n0 155.103
R24 VPB.t0 VPB.t2 272.274
R25 VPB.t2 VPB.t1 248.599
R26 VPB VPB.t0 201.246
R27 VNB.t0 VNB.t2 1310.03
R28 VNB.t2 VNB.t1 1196.12
R29 VNB VNB.t0 968.285
R30 a_203_47.t0 a_203_47.t1 49.8467
R31 a_111_297.n0 a_111_297.t1 598.37
R32 a_111_297.n0 a_111_297.t2 30.5355
R33 a_111_297.t0 a_111_297.n0 30.5355
C0 VPWR VGND 0.02172f
C1 A1 VGND 0.02084f
C2 Y VGND 0.03304f
C3 A1 VPWR 0.01558f
C4 VPWR Y 0.02261f
C5 A1 Y 0.02431f
C6 VPB B1 0.0381f
C7 VPB A2 0.02938f
C8 B1 VGND 0.02625f
C9 A2 VGND 0.02782f
C10 B1 VPWR 0.01383f
C11 VPB VGND 0.00796f
C12 A1 B1 0.02424f
C13 A2 VPWR 0.01465f
C14 A1 A2 0.03922f
C15 VPB VPWR 0.05077f
C16 B1 Y 0.05418f
C17 VPB A1 0.02563f
C18 A2 Y 0.00274f
C19 VPB Y 0.01405f
C20 VGND VNB 0.35223f
C21 VPWR VNB 0.35037f
C22 Y VNB 0.06033f
C23 A2 VNB 0.11202f
C24 A1 VNB 0.07599f
C25 B1 VNB 0.13015f
C26 VPB VNB 0.46791f
C27 a_111_297.t2 VNB 0.04222f
C28 a_111_297.t1 VNB 0.12957f
C29 a_111_297.n0 VNB 0.07394f
C30 a_111_297.t0 VNB 0.03774f
C31 a_203_47.t1 VNB 0.02892f
C32 a_203_47.t0 VNB 0.02517f
C33 VPB.t1 VNB 0.071f
C34 VPB.t2 VNB 0.0355f
C35 VPB.t0 VNB 0.03227f
C36 B1.n0 VNB 0.06568f
C37 A1.n0 VNB 0.0557f
C38 A2.n0 VNB 0.04525f
C39 Y.t0 VNB 0.08744f
C40 Y.t1 VNB 0.0312f
C41 Y.t2 VNB 0.02792f
C42 Y.n0 VNB 0.02238f
C43 Y.n1 VNB 0.0706f
C44 VPWR.t0 VNB 0.03307f
C45 VPWR.t1 VNB 0.03827f
C46 VPWR.n0 VNB 0.02183f
C47 VPWR.n1 VNB 0.06127f
C48 VGND.t1 VNB 0.02994f
C49 VGND.t0 VNB 0.03127f
C50 VGND.n0 VNB 0.05738f
C51 VGND.n1 VNB 0.02017f
.ends
