* NGSPICE file created from dd2_g5__a21oi_1.ext - technology: sky130A

.subckt dd2_g5__a21oi_1 A1 A2 B1 VGND VNB VPB VPWR Y
X0 a_255_47.t1 A1.t0 Y.t1 VNB.t2 sky130_fd_pr__nfet_01v8 ad=0.08775 pd=0.92 as=0.10725 ps=0.98 w=0.65 l=0.15
X1 a_159_297.t1 A2.t1 VPWR.t0 VPB.t1 sky130_fd_pr__pfet_01v8_hvt ad=0.26 pd=2.52 as=0.135 ps=1.27 w=1 l=0.15
X2 a_159_297.t0 B1.t1 Y.t0 VPB.t0 sky130_fd_pr__pfet_01v8_hvt ad=0.165 pd=1.33 as=0.26 ps=2.52 w=1 l=0.15
X3 VPWR.t1 A1.t1 a_159_297.t2 VPB.t2 sky130_fd_pr__pfet_01v8_hvt ad=0.135 pd=1.27 as=0.165 ps=1.33 w=1 l=0.15
X4 Y.t2 B1.t0 VGND.t1 VNB.t0 sky130_fd_pr__nfet_01v8 ad=0.10725 pd=0.98 as=0.169 ps=1.82 w=0.65 l=0.15
X5 VGND.t0 A2.t0 a_255_47.t0 VNB.t1 sky130_fd_pr__nfet_01v8 ad=0.169 pd=1.82 as=0.08775 ps=0.92 w=0.65 l=0.15
R0 VGND.n1 VGND.t0 289.449
R1 VGND.n0 VGND.t1 282.817
R2 VGND.n3 VGND.n2 9.3005
R3 VGND.n3 VGND.n0 8.65932
R4 VGND.n1 VGND.n0 8.56619
R5 VGND VGND.n3 6.77697
R6 VGND.n2 VGND.n1 0.310059
R7 VGND.n2 VGND 0.0239375
R8 VPWR.n1 VPWR.n0 619.693
R9 VPWR.n0 VPWR.t0 26.5955
R10 VPWR.n0 VPWR.t1 26.5955
R11 VPWR VPWR.n1 14.2454
R12 VPWR.n1 VPWR 0.183024
R13 Y.n1 Y.t0 926.915
R14 Y.n1 Y.n0 185
R15 Y.n0 Y.t1 30.462
R16 Y.n0 Y.t2 30.462
R17 Y Y.n1 5.1205
R18 A2.n0 A2.t1 241.536
R19 A2.n0 A2.t0 169.237
R20 A2 A2.n0 155.103
R21 A1.n0 A1.t1 241.536
R22 A1.n0 A1.t0 169.237
R23 A1 A1.n0 155.103
R24 B1.n0 B1.t1 241.536
R25 B1.n0 B1.t0 169.237
R26 B1 B1.n0 155.103
R27 VPB VPB.t0 343.303
R28 VPB.t0 VPB.t2 284.113
R29 VPB.t2 VPB.t1 248.599
R30 VNB VNB.t0 1651.78
R31 VNB.t0 VNB.t2 1366.99
R32 VNB.t2 VNB.t1 1196.12
R33 a_255_47.t0 a_255_47.t1 49.8467
R34 a_159_297.n0 a_159_297.t1 1481.76
R35 a_159_297.n0 a_159_297.t2 32.5055
R36 a_159_297.t0 a_159_297.n0 32.5055
C0 VGND A1 0.01962f
C1 VPWR VPB 0.08688f
C2 Y VPWR 0.01866f
C3 B1 A1 0.03636f
C4 VGND B1 0.01659f
C5 VPB A1 0.02591f
C6 VGND VPB 0.01532f
C7 Y A1 0.00408f
C8 Y VGND 0.05178f
C9 B1 VPB 0.03184f
C10 VPWR A2 0.01709f
C11 Y B1 0.04059f
C12 Y VPB 0.01428f
C13 A1 A2 0.03922f
C14 VGND A2 0.02276f
C15 VPB A2 0.03093f
C16 Y A2 0.00198f
C17 VPWR A1 0.01689f
C18 VGND VPWR 0.02754f
C19 VPWR B1 0.01757f
C20 VGND VNB 0.34728f
C21 VPWR VNB 0.39078f
C22 Y VNB 0.07948f
C23 A2 VNB 0.10968f
C24 A1 VNB 0.07499f
C25 B1 VNB 0.09949f
C26 VPB VNB 0.56547f
C27 a_159_297.t2 VNB 0.03951f
C28 a_159_297.t1 VNB 0.07701f
C29 a_159_297.n0 VNB 0.05116f
C30 a_159_297.t0 VNB 0.03704f
C31 a_255_47.t1 VNB 0.0272f
C32 a_255_47.t0 VNB 0.02381f
C33 VPB.t1 VNB 0.08589f
C34 VPB.t2 VNB 0.03579f
C35 VPB.t0 VNB 0.04215f
C36 B1.n0 VNB 0.04753f
C37 A1.n0 VNB 0.05251f
C38 A2.n0 VNB 0.04307f
C39 Y.t0 VNB 0.06981f
C40 Y.t1 VNB 0.02858f
C41 Y.t2 VNB 0.02679f
C42 Y.n0 VNB 0.01943f
C43 Y.n1 VNB 0.0606f
C44 VPWR.t0 VNB 0.03017f
C45 VPWR.t1 VNB 0.03486f
C46 VPWR.n0 VNB 0.01826f
C47 VPWR.n1 VNB 0.07425f
C48 VGND.t1 VNB 0.03018f
C49 VGND.n0 VNB 0.02121f
C50 VGND.t0 VNB 0.02914f
C51 VGND.n1 VNB 0.06282f
C52 VGND.n2 VNB 0.05299f
C53 VGND.n3 VNB 0.00147f
.ends
