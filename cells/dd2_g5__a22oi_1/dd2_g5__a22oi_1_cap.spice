* NGSPICE file created from dd2_g5__a22oi_1.ext - technology: sky130A

.subckt dd2_g5__a22oi_1 A B C D VGND VNB VPB VPWR Y
X0 a_27_297# B VPWR VPB sky130_fd_pr__pfet_01v8_hvt ad=0.165 pd=1.33 as=0.135 ps=1.27 w=1 l=0.15
X1 Y C a_27_297# VPB sky130_fd_pr__pfet_01v8_hvt ad=0.155 pd=1.31 as=0.165 ps=1.33 w=1 l=0.15
X2 Y B a_109_47# VNB sky130_fd_pr__nfet_01v8 ad=0.10725 pd=0.98 as=0.08775 ps=0.92 w=0.65 l=0.15
X3 a_27_297# D Y VPB sky130_fd_pr__pfet_01v8_hvt ad=0.26 pd=2.52 as=0.155 ps=1.31 w=1 l=0.15
X4 a_289_47# C Y VNB sky130_fd_pr__nfet_01v8 ad=0.10075 pd=0.96 as=0.10725 ps=0.98 w=0.65 l=0.15
X5 VGND D a_289_47# VNB sky130_fd_pr__nfet_01v8 ad=0.169 pd=1.82 as=0.10075 ps=0.96 w=0.65 l=0.15
X6 VPWR A a_27_297# VPB sky130_fd_pr__pfet_01v8_hvt ad=0.135 pd=1.27 as=0.26 ps=2.52 w=1 l=0.15
X7 a_109_47# A VGND VNB sky130_fd_pr__nfet_01v8 ad=0.08775 pd=0.92 as=0.169 ps=1.82 w=0.65 l=0.15
C0 A B 0.03922f
C1 B a_27_297# 0.02366f
C2 VPB VGND 0.00871f
C3 B Y 0.00439f
C4 VPB A 0.02928f
C5 C B 0.03636f
C6 VPB a_27_297# 0.01648f
C7 VPB Y 0.01034f
C8 C VPB 0.02655f
C9 VPWR B 0.01689f
C10 VGND A 0.02222f
C11 VGND a_27_297# 0.01598f
C12 VPB VPWR 0.06142f
C13 A a_27_297# 0.02148f
C14 VGND Y 0.04305f
C15 A Y 0.00213f
C16 C VGND 0.01392f
C17 VGND a_289_47# 0.00818f
C18 a_27_297# Y 0.03522f
C19 C a_27_297# 0.01802f
C20 a_289_47# a_27_297# 0
C21 C Y 0.0397f
C22 a_289_47# Y 0.00953f
C23 C a_289_47# 0
C24 a_109_47# B 0
C25 D VPB 0.038f
C26 VGND VPWR 0.02579f
C27 VPWR A 0.01687f
C28 VPWR a_27_297# 0.12926f
C29 VPWR Y 0.00864f
C30 C VPWR 0.00972f
C31 a_289_47# VPWR 0
C32 VGND a_109_47# 0.00983f
C33 D VGND 0.02634f
C34 a_109_47# a_27_297# 0.00238f
C35 D a_27_297# 0.01752f
C36 a_109_47# Y 0.00262f
C37 D Y 0.03196f
C38 C D 0.02424f
C39 VPB B 0.02591f
C40 a_109_47# VPWR 0.00122f
C41 D VPWR 0.00998f
C42 VGND B 0.01868f
C43 VGND VNB 0.3217f
C44 Y VNB 0.1386f
C45 VPWR VNB 0.32995f
C46 VPB VNB 0.51617f
C47 a_27_297# VNB 0.19842f
.ends
