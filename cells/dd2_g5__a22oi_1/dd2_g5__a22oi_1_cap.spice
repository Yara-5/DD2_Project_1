* NGSPICE file created from dd2_g5__a22oi_1.ext - technology: sky130A

.subckt dd2_g5__a22oi_1 A B C D VGND VNB VPB VPWR Y
X0 a_27_297# B VPWR VPB sky130_fd_pr__pfet_01v8_hvt ad=0.165 pd=1.33 as=0.135 ps=1.27 w=1 l=0.15
X1 Y C a_27_297# VPB sky130_fd_pr__pfet_01v8_hvt ad=0.155 pd=1.31 as=0.165 ps=1.33 w=1 l=0.15
X2 Y B a_109_47# VNB sky130_fd_pr__nfet_01v8 ad=0.10725 pd=0.98 as=0.08775 ps=0.92 w=0.65 l=0.15
X3 a_27_297# D Y VPB sky130_fd_pr__pfet_01v8_hvt ad=0.26 pd=2.52 as=0.155 ps=1.31 w=1 l=0.15
X4 a_289_47# C Y VNB sky130_fd_pr__nfet_01v8 ad=0.10075 pd=0.96 as=0.10725 ps=0.98 w=0.65 l=0.15
X5 VGND D a_289_47# VNB sky130_fd_pr__nfet_01v8 ad=0.169 pd=1.82 as=0.10075 ps=0.96 w=0.65 l=0.15
X6 VPWR A a_27_297# VPB sky130_fd_pr__pfet_01v8_hvt ad=0.135 pd=1.27 as=0.26 ps=2.52 w=1 l=0.15
X7 a_109_47# A VGND VNB sky130_fd_pr__nfet_01v8 ad=0.08775 pd=0.92 as=0.169 ps=1.82 w=0.65 l=0.15
C0 a_109_47# VPWR 0.00122f
C1 D VPWR 0.00974f
C2 VGND B 0.01982f
C3 A B 0.03922f
C4 B a_27_297# 0.02623f
C5 VPB VGND 0.00784f
C6 B Y 0.00778f
C7 VPB A 0.02928f
C8 C B 0.03636f
C9 VPB a_27_297# 0.02065f
C10 VPB Y 0.01052f
C11 C VPB 0.02655f
C12 VPWR B 0.01689f
C13 VGND A 0.0272f
C14 VGND a_27_297# 0.01571f
C15 VPB VPWR 0.05653f
C16 A a_27_297# 0.02763f
C17 VGND Y 0.06074f
C18 A Y 0.00281f
C19 C VGND 0.01358f
C20 VGND a_289_47# 0.00764f
C21 a_27_297# Y 0.03993f
C22 C a_27_297# 0.02115f
C23 a_289_47# a_27_297# 0
C24 C Y 0.04193f
C25 a_289_47# Y 0.01113f
C26 C a_289_47# 0
C27 a_109_47# B 0
C28 D VPB 0.038f
C29 VGND VPWR 0.02511f
C30 VPWR A 0.01537f
C31 VPWR a_27_297# 0.16002f
C32 VPWR Y 0.00838f
C33 C VPWR 0.00972f
C34 a_289_47# VPWR 0
C35 VGND a_109_47# 0.012f
C36 D VGND 0.02607f
C37 a_109_47# a_27_297# 0.00238f
C38 D a_27_297# 0.02214f
C39 a_109_47# Y 0.00413f
C40 D Y 0.03273f
C41 C D 0.02424f
C42 VPB B 0.02591f
C43 VGND VNB 0.33468f
C44 Y VNB 0.13218f
C45 VPWR VNB 0.32436f
C46 VPB VNB 0.51617f
C47 a_27_297# VNB 0.21701f
.ends
