* NGSPICE file created from dd2_g5__a22oi_1.ext - technology: sky130A

.subckt dd2_g5__a22oi_1 A B C D VGND VNB VPB VPWR Y
X0 a_27_297.t0 B.t1 VPWR.t0 VPB.t0 sky130_fd_pr__pfet_01v8_hvt ad=0.165 pd=1.33 as=0.135 ps=1.27 w=1 l=0.15
X1 Y.t3 C.t1 a_27_297.t3 VPB.t3 sky130_fd_pr__pfet_01v8_hvt ad=0.155 pd=1.31 as=0.165 ps=1.33 w=1 l=0.15
X2 Y.t0 B.t0 a_109_47.t0 VNB.t0 sky130_fd_pr__nfet_01v8 ad=0.10725 pd=0.98 as=0.08775 ps=0.92 w=0.65 l=0.15
X3 a_27_297.t2 D.t1 Y.t1 VPB.t2 sky130_fd_pr__pfet_01v8_hvt ad=0.26 pd=2.52 as=0.155 ps=1.31 w=1 l=0.15
X4 a_289_47.t1 C.t0 Y.t2 VNB.t3 sky130_fd_pr__nfet_01v8 ad=0.10075 pd=0.96 as=0.10725 ps=0.98 w=0.65 l=0.15
X5 VGND.t0 D.t0 a_289_47.t0 VNB.t2 sky130_fd_pr__nfet_01v8 ad=0.169 pd=1.82 as=0.10075 ps=0.96 w=0.65 l=0.15
X6 VPWR.t1 A.t1 a_27_297.t1 VPB.t1 sky130_fd_pr__pfet_01v8_hvt ad=0.135 pd=1.27 as=0.26 ps=2.52 w=1 l=0.15
X7 a_109_47.t1 A.t0 VGND.t1 VNB.t1 sky130_fd_pr__nfet_01v8 ad=0.08775 pd=0.92 as=0.169 ps=1.82 w=0.65 l=0.15
R0 VGND.n0 VGND.t0 290.132
R1 VGND.n1 VGND.t1 149.762
R2 VGND.n1 VGND.n0 6.9081
R3 VGND VGND.n1 3.10353
R4 VGND.n0 VGND 0.0797525
R5 Y.n1 Y.n0 672.189
R6 Y Y.n2 191.982
R7 Y.n2 Y.n1 188.103
R8 Y.n0 Y.t1 30.5355
R9 Y.n0 Y.t3 30.5355
R10 Y.n2 Y.t2 30.462
R11 Y.n2 Y.t0 30.462
R12 Y Y.n1 3.10353
R13 VPWR.n1 VPWR.n0 612.784
R14 VPWR.n0 VPWR.t0 26.5955
R15 VPWR.n0 VPWR.t1 26.5955
R16 VPWR VPWR.n1 12.8745
R17 VPWR.n1 VPWR 1.55386
R18 D.n0 D.t1 230.155
R19 D.n0 D.t0 157.856
R20 D D.n0 155.103
R21 C.n0 C.t1 241.536
R22 C.n0 C.t0 169.237
R23 C C.n0 155.103
R24 B.n0 B.t1 241.536
R25 B.n0 B.t0 169.237
R26 B B.n0 155.103
R27 A.n0 A.t1 241.536
R28 A.n0 A.t0 169.237
R29 A A.n0 155.103
R30 VPB.t0 VPB.t3 284.113
R31 VPB.t3 VPB.t2 272.274
R32 VPB.t1 VPB.t0 248.599
R33 VPB VPB.t1 195.327
R34 VNB.t0 VNB.t3 1366.99
R35 VNB.t3 VNB.t2 1310.03
R36 VNB.t1 VNB.t0 1196.12
R37 VNB VNB.t1 939.807
R38 a_289_47.t0 a_289_47.t1 57.2313
R39 a_109_47.t0 a_109_47.t1 49.8467
R40 a_27_297.n0 a_27_297.t2 378.925
R41 a_27_297.n0 a_27_297.t1 281.969
R42 a_27_297.n1 a_27_297.n0 189.28
R43 a_27_297.n1 a_27_297.t3 32.5055
R44 a_27_297.t0 a_27_297.n1 32.5055
C0 VPWR VPB 0.05653f
C1 Y B 0.00778f
C2 VPB C 0.02655f
C3 VGND Y 0.06074f
C4 VGND B 0.01982f
C5 VPB A 0.02928f
C6 Y D 0.03273f
C7 VGND D 0.02607f
C8 Y VPWR 0.00838f
C9 VPWR B 0.01689f
C10 Y C 0.04193f
C11 B C 0.03636f
C12 VGND VPWR 0.02511f
C13 VPWR D 0.00974f
C14 Y A 0.00281f
C15 B A 0.03922f
C16 VGND C 0.01358f
C17 D C 0.02424f
C18 VGND A 0.0272f
C19 Y VPB 0.01052f
C20 VPB B 0.02591f
C21 VPWR C 0.00972f
C22 VGND VPB 0.00784f
C23 VPWR A 0.01537f
C24 D VPB 0.038f
C25 VGND VNB 0.38105f
C26 Y VNB 0.07043f
C27 VPWR VNB 0.47034f
C28 D VNB 0.12927f
C29 C VNB 0.07693f
C30 B VNB 0.07626f
C31 A VNB 0.11241f
C32 VPB VNB 0.55593f
C33 a_27_297.t3 VNB 0.04366f
C34 a_27_297.t2 VNB 0.07589f
C35 a_27_297.t1 VNB 0.0833f
C36 a_27_297.n0 VNB 0.15909f
C37 a_27_297.n1 VNB 0.03117f
C38 a_27_297.t0 VNB 0.04346f
C39 a_109_47.t1 VNB 0.0265f
C40 a_109_47.t0 VNB 0.0301f
C41 a_289_47.t1 VNB 0.03015f
C42 a_289_47.t0 VNB 0.02559f
C43 VPB.t2 VNB 0.07149f
C44 VPB.t3 VNB 0.03775f
C45 VPB.t0 VNB 0.03615f
C46 VPB.t1 VNB 0.03012f
C47 A.n0 VNB 0.04607f
C48 B.n0 VNB 0.05612f
C49 C.n0 VNB 0.05651f
C50 D.n0 VNB 0.0618f
C51 VPWR.t0 VNB 0.03901f
C52 VPWR.t1 VNB 0.03401f
C53 VPWR.n0 VNB 0.02285f
C54 VPWR.n1 VNB 0.03731f
C55 Y.t1 VNB 0.03922f
C56 Y.t3 VNB 0.04548f
C57 Y.n0 VNB 0.03957f
C58 Y.n1 VNB 0.07477f
C59 Y.t2 VNB 0.03234f
C60 Y.t0 VNB 0.0322f
C61 Y.n2 VNB 0.02471f
C62 VGND.t0 VNB 0.03176f
C63 VGND.n0 VNB 0.10782f
C64 VGND.t1 VNB 0.03226f
C65 VGND.n1 VNB 0.03413f
.ends
