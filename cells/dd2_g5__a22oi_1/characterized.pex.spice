* NGSPICE file created from dd2_g5__a22oi_1.ext - technology: sky130A

.subckt dd2_g5__a22oi_1 A B C D VGND VNB VPB VPWR Y
X0 a_27_297.t0 B.t1 VPWR.t0 VPB.t0 sky130_fd_pr__pfet_01v8_hvt ad=0.165 pd=1.33 as=0.135 ps=1.27 w=1 l=0.15
X1 Y.t2 C.t1 a_27_297.t3 VPB.t3 sky130_fd_pr__pfet_01v8_hvt ad=0.155 pd=1.31 as=0.165 ps=1.33 w=1 l=0.15
X2 Y.t3 B.t0 a_109_47.t0 VNB.t0 sky130_fd_pr__nfet_01v8 ad=0.10725 pd=0.98 as=0.08775 ps=0.92 w=0.65 l=0.15
X3 a_27_297.t2 D.t1 Y.t0 VPB.t2 sky130_fd_pr__pfet_01v8_hvt ad=0.26 pd=2.52 as=0.155 ps=1.31 w=1 l=0.15
X4 a_289_47.t1 C.t0 Y.t1 VNB.t3 sky130_fd_pr__nfet_01v8 ad=0.10075 pd=0.96 as=0.10725 ps=0.98 w=0.65 l=0.15
X5 VGND.t0 D.t0 a_289_47.t0 VNB.t2 sky130_fd_pr__nfet_01v8 ad=0.169 pd=1.82 as=0.10075 ps=0.96 w=0.65 l=0.15
X6 VPWR.t1 A.t1 a_27_297.t1 VPB.t1 sky130_fd_pr__pfet_01v8_hvt ad=0.135 pd=1.27 as=0.26 ps=2.52 w=1 l=0.15
X7 a_109_47.t1 A.t0 VGND.t1 VNB.t1 sky130_fd_pr__nfet_01v8 ad=0.08775 pd=0.92 as=0.169 ps=1.82 w=0.65 l=0.15
R0 VGND.n0 VGND.t0 290.132
R1 VGND.n1 VGND.t1 282.817
R2 VGND.n1 VGND.n0 6.9081
R3 VGND VGND.n1 3.10353
R4 VGND.n0 VGND 0.0797525
R5 Y.n2 Y.n0 684.612
R6 Y.n2 Y.n1 185
R7 Y.n0 Y.t0 30.5355
R8 Y.n0 Y.t2 30.5355
R9 Y.n1 Y.t1 30.462
R10 Y.n1 Y.t3 30.462
R11 Y Y.n2 6.02403
R12 VPWR.n1 VPWR.n0 612.784
R13 VPWR.n0 VPWR.t0 26.5955
R14 VPWR.n0 VPWR.t1 26.5955
R15 VPWR VPWR.n1 12.8745
R16 VPWR.n1 VPWR 1.55386
R17 D.n0 D.t1 230.155
R18 D.n0 D.t0 157.856
R19 D D.n0 155.103
R20 C.n0 C.t1 241.536
R21 C.n0 C.t0 169.237
R22 C C.n0 155.103
R23 B.n0 B.t1 241.536
R24 B.n0 B.t0 169.237
R25 B B.n0 155.103
R26 A.n0 A.t1 241.536
R27 A.n0 A.t0 169.237
R28 A A.n0 155.103
R29 VPB.t0 VPB.t3 284.113
R30 VPB.t3 VPB.t2 272.274
R31 VPB.t1 VPB.t0 248.599
R32 VPB VPB.t1 195.327
R33 VNB.t0 VNB.t3 1366.99
R34 VNB.t3 VNB.t2 1310.03
R35 VNB.t1 VNB.t0 1196.12
R36 VNB VNB.t1 939.807
R37 a_289_47.t0 a_289_47.t1 57.2313
R38 a_109_47.t0 a_109_47.t1 49.8467
R39 a_27_297.n0 a_27_297.t1 935.157
R40 a_27_297.n0 a_27_297.t2 922.499
R41 a_27_297.n1 a_27_297.n0 585
R42 a_27_297.n1 a_27_297.t3 32.5055
R43 a_27_297.t0 a_27_297.n1 32.5055
C0 C B 0.03636f
C1 D VGND 0.02634f
C2 A VPWR 0.01687f
C3 VGND VPB 0.00871f
C4 Y VPWR 0.00864f
C5 A VPB 0.02928f
C6 B VPWR 0.01689f
C7 C VPWR 0.00972f
C8 D Y 0.03196f
C9 VGND A 0.02222f
C10 VPB Y 0.01034f
C11 C D 0.02424f
C12 VGND Y 0.04305f
C13 B VPB 0.02591f
C14 C VPB 0.02655f
C15 VGND B 0.01868f
C16 C VGND 0.01392f
C17 A Y 0.00213f
C18 A B 0.03922f
C19 D VPWR 0.00998f
C20 VPB VPWR 0.06142f
C21 B Y 0.00439f
C22 C Y 0.0397f
C23 VGND VPWR 0.02579f
C24 D VPB 0.038f
C25 VGND VNB 0.36706f
C26 Y VNB 0.05851f
C27 VPWR VNB 0.45911f
C28 D VNB 0.12876f
C29 C VNB 0.07634f
C30 B VNB 0.07545f
C31 A VNB 0.11121f
C32 VPB VNB 0.55619f
C33 a_27_297.t3 VNB 0.04436f
C34 a_27_297.t1 VNB 0.07409f
C35 a_27_297.t2 VNB 0.07155f
C36 a_27_297.n0 VNB 0.10837f
C37 a_27_297.n1 VNB 0.03419f
C38 a_27_297.t0 VNB 0.04383f
C39 a_109_47.t1 VNB 0.02345f
C40 a_109_47.t0 VNB 0.02743f
C41 a_289_47.t1 VNB 0.02903f
C42 a_289_47.t0 VNB 0.02457f
C43 VPB.t2 VNB 0.07196f
C44 VPB.t3 VNB 0.038f
C45 VPB.t0 VNB 0.03638f
C46 VPB.t1 VNB 0.03032f
C47 A.n0 VNB 0.04272f
C48 B.n0 VNB 0.05381f
C49 C.n0 VNB 0.05488f
C50 D.n0 VNB 0.05983f
C51 VPWR.t0 VNB 0.03701f
C52 VPWR.t1 VNB 0.0315f
C53 VPWR.n0 VNB 0.02111f
C54 VPWR.n1 VNB 0.03446f
C55 Y.t0 VNB 0.03761f
C56 Y.t2 VNB 0.04375f
C57 Y.n0 VNB 0.03859f
C58 Y.t1 VNB 0.03112f
C59 Y.t3 VNB 0.03074f
C60 Y.n1 VNB 0.02282f
C61 Y.n2 VNB 0.06874f
C62 VGND.t0 VNB 0.03032f
C63 VGND.n0 VNB 0.1015f
C64 VGND.t1 VNB 0.02975f
C65 VGND.n1 VNB 0.02214f
.ends
