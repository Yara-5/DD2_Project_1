* NGSPICE file created from dd2_g5__and2_opt_1.ext - technology: sky130A

.subckt dd2_g5__and2_opt_1 A B VGND VNB VPB VPWR Y
X0 VGND.t0 A.t0 a_149_47.t0 VNB.t1 sky130_fd_pr__nfet_01v8 ad=0.10725 pd=0.98 as=0.08775 ps=0.92 w=0.65 l=0.15
X1 a_149_47.t1 B.t0 a_67_47.t2 VNB.t2 sky130_fd_pr__nfet_01v8 ad=0.08775 pd=0.92 as=0.169 ps=1.82 w=0.65 l=0.15
X2 Y.t0 a_67_47.t4 VPWR.t2 VPB.t0 sky130_fd_pr__pfet_01v8_hvt ad=0.26 pd=2.52 as=0.143 ps=1.33 w=1 l=0.15
X3 Y.t1 a_67_47.t3 VGND.t1 VNB.t0 sky130_fd_pr__nfet_01v8 ad=0.169 pd=1.82 as=0.10725 ps=0.98 w=0.65 l=0.15
X4 VPWR.t0 A.t1 a_67_47.t0 VPB.t1 sky130_fd_pr__pfet_01v8_hvt ad=0.143 pd=1.33 as=0.06075 ps=0.72 w=0.45 l=0.15
X5 a_67_47.t1 B.t1 VPWR.t1 VPB.t2 sky130_fd_pr__pfet_01v8_hvt ad=0.06075 pd=0.72 as=0.117 ps=1.42 w=0.45 l=0.15
R0 VGND.n1 VGND.n0 116.132
R1 VGND.n0 VGND.t1 30.462
R2 VGND.n0 VGND.t0 30.462
R3 VGND VGND.n1 14.1864
R4 VGND.n1 VGND 0.240312
R5 Y.n0 Y.t0 389.846
R6 Y.n0 Y.t1 209.923
R7 Y.n1 Y 6.4005
R8 Y Y.n1 3.2005
R9 Y.n1 Y.n0 0.213833
R10 VPWR.n0 VPWR.t1 666.312
R11 VPWR.n2 VPWR.n1 618.59
R12 VPWR.n1 VPWR.t0 72.2338
R13 VPWR.n1 VPWR.t2 42.1366
R14 VPWR.n2 VPWR.n0 23.9894
R15 VPWR.n4 VPWR.n0 17.3181
R16 VPWR.n4 VPWR.n3 9.3005
R17 VPWR VPWR.n4 6.77697
R18 VPWR.n3 VPWR.n2 1.07665
R19 VPWR.n3 VPWR 0.0239375
R20 A.n0 A.t1 329.902
R21 A.n0 A.t0 169.237
R22 A A.n0 155.103
R23 B.n0 B.t1 329.902
R24 B.n0 B.t0 169.237
R25 B B.n0 155.103
R26 VPB VPB.t2 313.707
R27 VPB.t1 VPB.t0 284.113
R28 VPB.t2 VPB.t1 248.599
R29 VNB VNB.t2 1509.39
R30 VNB.t1 VNB.t0 1366.99
R31 VNB.t2 VNB.t1 1196.12
R32 a_149_47.t0 a_149_47.t1 49.8467
R33 a_67_47.n2 a_67_47.n0 623.777
R34 a_67_47.t2 a_67_47.n2 244.887
R35 a_67_47.n1 a_67_47.t4 241.536
R36 a_67_47.n2 a_67_47.n1 214.006
R37 a_67_47.n1 a_67_47.t3 169.237
R38 a_67_47.n0 a_67_47.t0 59.1005
R39 a_67_47.n0 a_67_47.t1 59.1005
C0 VPB VGND 0.01461f
C1 VPWR A 0.01816f
C2 VPWR VGND 0.02636f
C3 VPB Y 0.01768f
C4 VPWR Y 0.0235f
C5 B A 0.05551f
C6 B VGND 0.01683f
C7 B Y 0
C8 VPWR VPB 0.09239f
C9 B VPB 0.06946f
C10 B VPWR 0.01854f
C11 A VGND 0.02451f
C12 Y A 0.00408f
C13 Y VGND 0.03406f
C14 VPB A 0.0685f
C15 VGND VNB 0.43134f
C16 Y VNB 0.06805f
C17 VPWR VNB 0.27901f
C18 A VNB 0.09093f
C19 B VNB 0.11857f
C20 VPB VNB 0.58943f
C21 a_67_47.t0 VNB 0.04277f
C22 a_67_47.t1 VNB 0.03977f
C23 a_67_47.n0 VNB 0.01886f
C24 a_67_47.n1 VNB 0.05598f
C25 a_67_47.n2 VNB 0.17255f
C26 a_67_47.t2 VNB 0.10661f
C27 a_149_47.t1 VNB 0.03616f
C28 a_149_47.t0 VNB 0.03868f
C29 VPB.t0 VNB 0.14282f
C30 VPB.t1 VNB 0.05541f
C31 VPB.t2 VNB 0.05848f
C32 B.n0 VNB 0.08233f
C33 A.n0 VNB 0.09029f
C34 VPWR.t1 VNB 0.04532f
C35 VPWR.n0 VNB 0.01813f
C36 VPWR.t2 VNB 0.03768f
C37 VPWR.t0 VNB 0.03877f
C38 VPWR.n1 VNB 0.01716f
C39 VPWR.n2 VNB 0.04631f
C40 VPWR.n3 VNB 0.12977f
C41 VPWR.n4 VNB 0.00351f
C42 Y.t0 VNB 0.07056f
C43 Y.t1 VNB 0.0426f
C44 Y.n0 VNB 0.05085f
C45 Y.n1 VNB 0.00553f
C46 VGND.t1 VNB 0.02162f
C47 VGND.t0 VNB 0.03416f
C48 VGND.n0 VNB 0.01665f
C49 VGND.n1 VNB 0.06661f
.ends
