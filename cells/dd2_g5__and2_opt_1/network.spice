* dd2_g5__and2_opt_1: Y = A & B
* Generated by synthesize.py; stages in signal order:
*   n1 = !(A & B)
*   Y = !(n1)
.subckt dd2_g5__and2_opt_1 A B VGND VNB VPB VPWR Y
XN1 n1 A n1_d1 VNB sky130_fd_pr__nfet_01v8 w=0.65 l=0.15
XN2 n1_d1 B VGND VNB sky130_fd_pr__nfet_01v8 w=0.65 l=0.15
XP1 n1 A VPWR VPB sky130_fd_pr__pfet_01v8_hvt w=0.45 l=0.15
XP2 n1 B VPWR VPB sky130_fd_pr__pfet_01v8_hvt w=0.45 l=0.15
XN3 Y n1 VGND VNB sky130_fd_pr__nfet_01v8 w=0.65 l=0.15
XP3 Y n1 VPWR VPB sky130_fd_pr__pfet_01v8_hvt w=1 l=0.15
.ends dd2_g5__and2_opt_1
