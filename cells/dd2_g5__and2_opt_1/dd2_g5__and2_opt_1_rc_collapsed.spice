.subckt dd2_g5__and2_opt_1 A B VGND VNB VPB VPWR Y
X0 VGND A a_149_47.t0 VNB sky130_fd_pr__nfet_01v8 ad=0.10725 pd=0.98 as=0.08775 ps=0.92 w=0.65 l=0.15
X1 a_149_47.t0 B a_67_47.t2 VNB sky130_fd_pr__nfet_01v8 ad=0.08775 pd=0.92 as=0.169 ps=1.82 w=0.65 l=0.15
X2 Y a_67_47.t2 VPWR VPB sky130_fd_pr__pfet_01v8_hvt ad=0.26 pd=2.52 as=0.143 ps=1.33 w=1 l=0.15
X3 Y a_67_47.t2 VGND VNB sky130_fd_pr__nfet_01v8 ad=0.169 pd=1.82 as=0.10725 ps=0.98 w=0.65 l=0.15
X4 VPWR A a_67_47.t2 VPB sky130_fd_pr__pfet_01v8_hvt ad=0.143 pd=1.33 as=0.06075 ps=0.72 w=0.45 l=0.15
X5 a_67_47.t2 B VPWR VPB sky130_fd_pr__pfet_01v8_hvt ad=0.06075 pd=0.72 as=0.117 ps=1.42 w=0.45 l=0.15
.ends dd2_g5__and2_opt_1
