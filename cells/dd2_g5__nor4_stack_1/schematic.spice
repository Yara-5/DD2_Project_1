* Intended schematic from supplied transistor connections.
* SKY130 model files use um-scale W/L convention; load the course model setup.
.subckt dd2_g5__nor4_stack_1 A B C D VGND VNB VPB VPWR Y
XN1 n1 B VGND VNB sky130_fd_pr__nfet_01v8 w=0.65 l=0.15
XN2 n1 C VGND VNB sky130_fd_pr__nfet_01v8 w=0.65 l=0.15
XN3 n1 D VGND VNB sky130_fd_pr__nfet_01v8 w=0.65 l=0.15
XP1 VPWR B n1_u1 VPB sky130_fd_pr__pfet_01v8_hvt w=1 l=0.15
XP2 n1_u1 C n1_u2 VPB sky130_fd_pr__pfet_01v8_hvt w=1 l=0.15
XP3 n1_u2 D n1 VPB sky130_fd_pr__pfet_01v8_hvt w=1 l=0.15
XN4 n2 n1 VGND VNB sky130_fd_pr__nfet_01v8 w=0.65 l=0.15
XP4 VPWR n1 n2 VPB sky130_fd_pr__pfet_01v8_hvt w=1 l=0.15
XN5 Y A VGND VNB sky130_fd_pr__nfet_01v8 w=0.65 l=0.15
XN6 Y n2 VGND VNB sky130_fd_pr__nfet_01v8 w=0.65 l=0.15
XP5_f1 VPWR A Y_u1 VPB sky130_fd_pr__pfet_01v8_hvt w=1 l=0.15
XP5_f2 VPWR A Y_u1 VPB sky130_fd_pr__pfet_01v8_hvt w=1 l=0.15
XP6_f1 Y_u1 n2 Y VPB sky130_fd_pr__pfet_01v8_hvt w=1 l=0.15
XP6_f2 Y_u1 n2 Y VPB sky130_fd_pr__pfet_01v8_hvt w=1 l=0.15
.ends dd2_g5__nor4_stack_1
