* NGSPICE file created from dd2_g5__nor4_stack_1.ext - technology: sky130A

.subckt dd2_g5__nor4_stack_1 A B C D VGND VNB VPB VPWR Y
X0 a_121_297.t1 D.t1 a_39_47.t2 VPB.t1 sky130_fd_pr__pfet_01v8_hvt ad=0.165 pd=1.33 as=0.26 ps=2.52 w=1 l=0.15
X1 VGND.t0 A.t0 Y.t0 VNB.t4 sky130_fd_pr__nfet_01v8 ad=0.169 pd=1.82 as=0.08775 ps=0.92 w=0.65 l=0.15
X2 Y.t2 a_397_47.t2 VGND.t3 VNB.t2 sky130_fd_pr__nfet_01v8 ad=0.08775 pd=0.92 as=0.169 ps=1.82 w=0.65 l=0.15
X3 a_397_47.t1 a_39_47.t5 VPWR.t3 VPB.t4 sky130_fd_pr__pfet_01v8_hvt ad=0.26 pd=2.52 as=0.135 ps=1.27 w=1 l=0.15
X4 VGND.t1 B.t0 a_39_47.t3 VNB.t5 sky130_fd_pr__nfet_01v8 ad=0.08775 pd=0.92 as=0.10725 ps=0.98 w=0.65 l=0.15
X5 a_503_297.t3 A.t1 VPWR.t1 VPB.t6 sky130_fd_pr__pfet_01v8_hvt ad=0.26 pd=2.52 as=0.135 ps=1.27 w=1 l=0.15
X6 VGND.t4 D.t0 a_39_47.t1 VNB.t1 sky130_fd_pr__nfet_01v8 ad=0.10725 pd=0.98 as=0.169 ps=1.82 w=0.65 l=0.15
X7 VPWR.t0 B.t1 a_217_297.t1 VPB.t7 sky130_fd_pr__pfet_01v8_hvt ad=0.135 pd=1.27 as=0.165 ps=1.33 w=1 l=0.15
X8 a_217_297.t0 C.t1 a_121_297.t0 VPB.t0 sky130_fd_pr__pfet_01v8_hvt ad=0.165 pd=1.33 as=0.165 ps=1.33 w=1 l=0.15
X9 a_39_47.t0 C.t0 VGND.t2 VNB.t0 sky130_fd_pr__nfet_01v8 ad=0.10725 pd=0.98 as=0.10725 ps=0.98 w=0.65 l=0.15
X10 VPWR.t2 A.t2 a_503_297.t2 VPB.t5 sky130_fd_pr__pfet_01v8_hvt ad=0.135 pd=1.27 as=0.135 ps=1.27 w=1 l=0.15
X11 a_503_297.t1 a_397_47.t3 Y.t3 VPB.t3 sky130_fd_pr__pfet_01v8_hvt ad=0.135 pd=1.27 as=0.135 ps=1.27 w=1 l=0.15
X12 a_397_47.t0 a_39_47.t4 VGND.t5 VNB.t3 sky130_fd_pr__nfet_01v8 ad=0.169 pd=1.82 as=0.08775 ps=0.92 w=0.65 l=0.15
X13 Y.t1 a_397_47.t4 a_503_297.t0 VPB.t2 sky130_fd_pr__pfet_01v8_hvt ad=0.135 pd=1.27 as=0.26 ps=2.52 w=1 l=0.15
R0 VGND.n5 VGND.t0 288.224
R1 VGND.n4 VGND.t3 282.817
R2 VGND.n1 VGND.n0 199.739
R3 VGND.n10 VGND.n9 199.739
R4 VGND.n8 VGND.n3 34.6358
R5 VGND.n0 VGND.t4 30.462
R6 VGND.n0 VGND.t2 30.462
R7 VGND.n11 VGND.n10 28.9887
R8 VGND.n15 VGND.n1 28.2358
R9 VGND.n4 VGND.n3 27.4829
R10 VGND.n9 VGND.t1 24.9236
R11 VGND.n9 VGND.t5 24.9236
R12 VGND.n11 VGND.n1 16.1887
R13 VGND.n10 VGND.n8 15.4358
R14 VGND.n12 VGND.n11 9.3005
R15 VGND.n10 VGND.n2 9.3005
R16 VGND.n8 VGND.n7 9.3005
R17 VGND.n6 VGND.n3 9.3005
R18 VGND.n13 VGND.n1 9.3005
R19 VGND.n15 VGND.n14 9.3005
R20 VGND VGND.n15 6.77697
R21 VGND.n5 VGND.n4 6.17809
R22 VGND.n6 VGND.n5 0.653571
R23 VGND.n14 VGND.n13 0.120292
R24 VGND.n13 VGND.n12 0.120292
R25 VGND.n12 VGND.n2 0.120292
R26 VGND.n7 VGND.n2 0.120292
R27 VGND.n7 VGND.n6 0.120292
R28 VGND.n14 VGND 0.0239375
R29 Y.n2 Y.n0 746.38
R30 Y.n2 Y.n1 185
R31 Y.n0 Y.t3 26.5955
R32 Y.n0 Y.t1 26.5955
R33 Y.n1 Y.t0 24.9236
R34 Y.n1 Y.t2 24.9236
R35 Y Y.n2 6.02403
R36 VPWR.n4 VPWR.n3 614.62
R37 VPWR.n5 VPWR.n2 320.976
R38 VPWR.n5 VPWR.n4 35.4511
R39 VPWR.n11 VPWR.n0 34.6358
R40 VPWR.n7 VPWR.n0 34.6358
R41 VPWR.n7 VPWR.n6 34.6358
R42 VPWR.n3 VPWR.t2 26.5955
R43 VPWR.n3 VPWR.t1 26.5955
R44 VPWR.n2 VPWR.t0 26.5955
R45 VPWR.n2 VPWR.t3 26.5955
R46 VPWR.n11 VPWR.n10 9.3005
R47 VPWR.n9 VPWR.n0 9.3005
R48 VPWR.n8 VPWR.n7 9.3005
R49 VPWR.n6 VPWR.n1 9.3005
R50 VPWR VPWR.n11 6.77697
R51 VPWR.n6 VPWR.n5 6.77697
R52 VPWR.n4 VPWR.n1 0.15599
R53 VPWR.n10 VPWR.n9 0.120292
R54 VPWR.n9 VPWR.n8 0.120292
R55 VPWR.n8 VPWR.n1 0.120292
R56 VPWR.n10 VPWR 0.0239375
R57 A.n0 A.t1 273.425
R58 A.n0 A.t2 212.081
R59 A A.n0 155.103
R60 A.n0 A.t0 139.78
R61 B.n0 B.t1 241.536
R62 B.n0 B.t0 169.237
R63 B B.n0 155.103
R64 C.n0 C.t1 241.536
R65 C.n0 C.t0 169.237
R66 C C.n0 155.103
R67 D.n0 D.t1 241.536
R68 D.n0 D.t0 169.237
R69 D D.n0 155.103
R70 VPB.t4 VPB.t2 556.386
R71 VPB.t0 VPB.t7 284.113
R72 VPB.t1 VPB.t0 284.113
R73 VPB.t5 VPB.t6 248.599
R74 VPB.t3 VPB.t5 248.599
R75 VPB.t2 VPB.t3 248.599
R76 VPB.t7 VPB.t4 248.599
R77 VPB VPB.t1 230.841
R78 VNB.t3 VNB.t2 3873.14
R79 VNB.t0 VNB.t5 1366.99
R80 VNB.t1 VNB.t0 1366.99
R81 VNB.t2 VNB.t4 1196.12
R82 VNB.t5 VNB.t3 1196.12
R83 VNB VNB.t1 1110.68
R84 a_503_297.n0 a_503_297.t0 387.522
R85 a_503_297.n0 a_503_297.t3 367.604
R86 a_503_297.n1 a_503_297.n0 292.5
R87 a_503_297.t2 a_503_297.n1 26.5955
R88 a_503_297.n1 a_503_297.t1 26.5955
R89 a_217_297.t0 a_217_297.t1 65.0105
R90 a_121_297.t0 a_121_297.t1 65.0105
R91 a_397_47.t1 a_397_47.n2 393.14
R92 a_397_47.n2 a_397_47.t0 272.945
R93 a_397_47.n1 a_397_47.t4 264.663
R94 a_397_47.n2 a_397_47.n1 231.06
R95 a_397_47.n0 a_397_47.t3 212.081
R96 a_397_47.n0 a_397_47.t2 139.78
R97 a_397_47.n1 a_397_47.n0 8.76414
R98 a_39_47.n3 a_39_47.n0 285.137
R99 a_39_47.n2 a_39_47.t1 268.077
R100 a_39_47.n2 a_39_47.n1 255.024
R101 a_39_47.n0 a_39_47.t5 241.536
R102 a_39_47.t2 a_39_47.n3 228.19
R103 a_39_47.n0 a_39_47.t4 169.237
R104 a_39_47.n3 a_39_47.n2 70.024
R105 a_39_47.n1 a_39_47.t3 30.462
R106 a_39_47.n1 a_39_47.t0 30.462
C0 VPWR B 0.02007f
C1 B VPB 0.02588f
C2 A VGND 0.02129f
C3 Y VGND 0.04866f
C4 VGND VPWR 0.04803f
C5 VGND VPB 0.01186f
C6 VGND B 0.02142f
C7 VPWR D 0.01287f
C8 D VPB 0.03049f
C9 C VPWR 0.01582f
C10 VGND D 0.01585f
C11 C VPB 0.02683f
C12 C B 0.03636f
C13 C VGND 0.01758f
C14 Y A 0.07088f
C15 A VPWR 0.0285f
C16 Y VPWR 0.01725f
C17 A VPB 0.05764f
C18 C D 0.03636f
C19 Y VPB 0.01075f
C20 VPWR VPB 0.12706f
C21 VGND VNB 0.58862f
C22 Y VNB 0.05335f
C23 VPWR VNB 0.45664f
C24 A VNB 0.13941f
C25 B VNB 0.07589f
C26 C VNB 0.07712f
C27 D VNB 0.1022f
C28 VPB VNB 1.00516f
C29 a_39_47.n0 VNB 0.06452f
C30 a_39_47.t3 VNB 0.03349f
C31 a_39_47.t0 VNB 0.03369f
C32 a_39_47.n1 VNB 0.03409f
C33 a_39_47.t1 VNB 0.05592f
C34 a_39_47.n2 VNB 0.06714f
C35 a_39_47.n3 VNB 0.1554f
C36 a_39_47.t2 VNB 0.08684f
C37 a_397_47.n0 VNB 0.02837f
C38 a_397_47.n1 VNB 0.0552f
C39 a_397_47.t0 VNB 0.05121f
C40 a_397_47.n2 VNB 0.14832f
C41 a_397_47.t1 VNB 0.09155f
C42 a_121_297.t1 VNB 0.04255f
C43 a_121_297.t0 VNB 0.04508f
C44 a_217_297.t1 VNB 0.04487f
C45 a_217_297.t0 VNB 0.04514f
C46 a_503_297.t1 VNB 0.03175f
C47 a_503_297.t3 VNB 0.0857f
C48 a_503_297.t0 VNB 0.08175f
C49 a_503_297.n0 VNB 0.13648f
C50 a_503_297.n1 VNB 0.02865f
C51 a_503_297.t2 VNB 0.03677f
C52 VPB.t6 VNB 0.07801f
C53 VPB.t5 VNB 0.03681f
C54 VPB.t3 VNB 0.03681f
C55 VPB.t2 VNB 0.0596f
C56 VPB.t4 VNB 0.0596f
C57 VPB.t7 VNB 0.03944f
C58 VPB.t0 VNB 0.04207f
C59 VPB.t1 VNB 0.03813f
C60 D.n0 VNB 0.05148f
C61 C.n0 VNB 0.05656f
C62 B.n0 VNB 0.05601f
C63 A.n0 VNB 0.09635f
C64 VPWR.n0 VNB 0.01256f
C65 VPWR.n1 VNB 0.05582f
C66 VPWR.t3 VNB 0.02989f
C67 VPWR.t0 VNB 0.03867f
C68 VPWR.n2 VNB 0.02327f
C69 VPWR.t1 VNB 0.03839f
C70 VPWR.t2 VNB 0.03335f
C71 VPWR.n3 VNB 0.02245f
C72 VPWR.n4 VNB 0.27523f
C73 VPWR.n5 VNB 0.02953f
C74 VPWR.n6 VNB 0.00751f
C75 VPWR.n7 VNB 0.01256f
C76 VPWR.n8 VNB 0.03545f
C77 VPWR.n9 VNB 0.03545f
C78 VPWR.n10 VNB 0.02119f
C79 VPWR.n11 VNB 0.00751f
C80 Y.t3 VNB 0.03673f
C81 Y.t1 VNB 0.03996f
C82 Y.n0 VNB 0.05345f
C83 Y.t0 VNB 0.02828f
C84 Y.t2 VNB 0.02476f
C85 Y.n1 VNB 0.02501f
C86 Y.n2 VNB 0.11345f
C87 VGND.t2 VNB 0.02509f
C88 VGND.t4 VNB 0.02327f
C89 VGND.n0 VNB 0.01015f
C90 VGND.n1 VNB 0.02004f
C91 VGND.n2 VNB 0.01967f
C92 VGND.n3 VNB 0.00625f
C93 VGND.t0 VNB 0.03014f
C94 VGND.t3 VNB 0.02613f
C95 VGND.n4 VNB 0.02273f
C96 VGND.n5 VNB 0.04498f
C97 VGND.n6 VNB 0.08346f
C98 VGND.n7 VNB 0.01967f
C99 VGND.n8 VNB 0.00504f
C100 VGND.t5 VNB 0.01768f
C101 VGND.t1 VNB 0.02403f
C102 VGND.n9 VNB 0.00842f
C103 VGND.n10 VNB 0.02004f
C104 VGND.n11 VNB 0.00454f
C105 VGND.n12 VNB 0.01967f
C106 VGND.n13 VNB 0.01967f
C107 VGND.n14 VNB 0.01176f
C108 VGND.n15 VNB 0.00352f
.ends
