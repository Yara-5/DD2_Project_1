* NGSPICE file created from dd2_g5__nor4_stack_1.ext - technology: sky130A

.subckt dd2_g5__nor4_stack_1 A B C D VGND VNB VPB VPWR Y
X0 a_121_297# D a_39_47# VPB sky130_fd_pr__pfet_01v8_hvt ad=0.165 pd=1.33 as=0.26 ps=2.52 w=1 l=0.15
X1 VGND A Y VNB sky130_fd_pr__nfet_01v8 ad=0.169 pd=1.82 as=0.08775 ps=0.92 w=0.65 l=0.15
X2 Y a_397_47# VGND VNB sky130_fd_pr__nfet_01v8 ad=0.08775 pd=0.92 as=0.169 ps=1.82 w=0.65 l=0.15
X3 a_397_47# a_39_47# VPWR VPB sky130_fd_pr__pfet_01v8_hvt ad=0.26 pd=2.52 as=0.135 ps=1.27 w=1 l=0.15
X4 VGND B a_39_47# VNB sky130_fd_pr__nfet_01v8 ad=0.08775 pd=0.92 as=0.10725 ps=0.98 w=0.65 l=0.15
X5 a_503_297# A VPWR VPB sky130_fd_pr__pfet_01v8_hvt ad=0.26 pd=2.52 as=0.135 ps=1.27 w=1 l=0.15
X6 VGND D a_39_47# VNB sky130_fd_pr__nfet_01v8 ad=0.10725 pd=0.98 as=0.169 ps=1.82 w=0.65 l=0.15
X7 VPWR B a_217_297# VPB sky130_fd_pr__pfet_01v8_hvt ad=0.135 pd=1.27 as=0.165 ps=1.33 w=1 l=0.15
X8 a_217_297# C a_121_297# VPB sky130_fd_pr__pfet_01v8_hvt ad=0.165 pd=1.33 as=0.165 ps=1.33 w=1 l=0.15
X9 a_39_47# C VGND VNB sky130_fd_pr__nfet_01v8 ad=0.10725 pd=0.98 as=0.10725 ps=0.98 w=0.65 l=0.15
X10 VPWR A a_503_297# VPB sky130_fd_pr__pfet_01v8_hvt ad=0.135 pd=1.27 as=0.135 ps=1.27 w=1 l=0.15
X11 a_503_297# a_397_47# Y VPB sky130_fd_pr__pfet_01v8_hvt ad=0.135 pd=1.27 as=0.135 ps=1.27 w=1 l=0.15
X12 a_397_47# a_39_47# VGND VNB sky130_fd_pr__nfet_01v8 ad=0.169 pd=1.82 as=0.08775 ps=0.92 w=0.65 l=0.15
X13 Y a_397_47# a_503_297# VPB sky130_fd_pr__pfet_01v8_hvt ad=0.135 pd=1.27 as=0.26 ps=2.52 w=1 l=0.15
C0 D VPB 0.03049f
C1 a_503_297# VGND 0.00939f
C2 A VPWR 0.0285f
C3 C a_217_297# 0
C4 C VPWR 0.01582f
C5 C a_39_47# 0.04013f
C6 VPWR a_217_297# 0.01646f
C7 a_217_297# a_39_47# 0.01464f
C8 VPWR a_39_47# 0.09098f
C9 VGND VPB 0.01186f
C10 Y VGND 0.04866f
C11 B VPB 0.02588f
C12 a_503_297# a_397_47# 0.05782f
C13 A a_503_297# 0.02672f
C14 a_503_297# VPWR 0.1336f
C15 a_397_47# VPB 0.0742f
C16 Y a_397_47# 0.04491f
C17 a_503_297# a_39_47# 0
C18 D a_121_297# 0
C19 A VPB 0.05764f
C20 A Y 0.07088f
C21 C VPB 0.02683f
C22 D VGND 0.01585f
C23 VPWR VPB 0.12706f
C24 Y VPWR 0.01725f
C25 VPB a_39_47# 0.05569f
C26 VGND a_121_297# 0.00203f
C27 B VGND 0.02142f
C28 D a_397_47# 0
C29 D C 0.03636f
C30 a_397_47# a_121_297# 0
C31 a_503_297# VPB 0.01607f
C32 a_503_297# Y 0.06901f
C33 D VPWR 0.01287f
C34 VGND a_397_47# 0.07867f
C35 D a_39_47# 0.06224f
C36 C a_121_297# 0
C37 B a_397_47# 0.00221f
C38 A VGND 0.02129f
C39 VPWR a_121_297# 0.01432f
C40 C VGND 0.01758f
C41 a_121_297# a_39_47# 0.01703f
C42 Y VPB 0.01075f
C43 C B 0.03636f
C44 VGND a_217_297# 0.00203f
C45 VGND VPWR 0.04803f
C46 VGND a_39_47# 0.09916f
C47 B a_217_297# 0
C48 B VPWR 0.02007f
C49 B a_39_47# 0.06611f
C50 A a_397_47# 0.04026f
C51 C a_397_47# 0
C52 a_397_47# a_217_297# 0
C53 a_397_47# VPWR 0.07623f
C54 a_397_47# a_39_47# 0.06605f
C55 VGND VNB 0.73911f
C56 Y VNB 0.2276f
C57 VPWR VNB 0.53285f
C58 VPB VNB 0.95915f
C59 a_503_297# VNB 0.07925f
C60 a_217_297# VNB 0.02808f
C61 a_121_297# VNB 0.06968f
.ends
