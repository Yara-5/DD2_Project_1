* NGSPICE file created from dd2_g5__xor2_opt_1.ext - technology: sky130A

.subckt dd2_g5__xor2_opt_1 A B VGND VNB VPB VPWR Y
X0 a_111_343# B a_29_343# VPB sky130_fd_pr__pfet_01v8_hvt ad=0.10395 pd=1.04 as=0.2002 ps=2.06 w=0.77 l=0.15
X1 Y a_29_343# VGND VNB sky130_fd_pr__nfet_01v8 ad=0.10725 pd=0.98 as=0.10685 ps=0.98 w=0.65 l=0.15
X2 VGND A a_29_343# VNB sky130_fd_pr__nfet_01v8 ad=0.10685 pd=0.98 as=0.0864 ps=0.91 w=0.64 l=0.15
X3 a_29_343# B VGND VNB sky130_fd_pr__nfet_01v8 ad=0.0864 pd=0.91 as=0.1664 ps=1.8 w=0.64 l=0.15
X4 VGND A a_387_47# VNB sky130_fd_pr__nfet_01v8 ad=0.169 pd=1.82 as=0.08775 ps=0.92 w=0.65 l=0.15
X5 a_387_47# B Y VNB sky130_fd_pr__nfet_01v8 ad=0.08775 pd=0.92 as=0.10725 ps=0.98 w=0.65 l=0.15
X6 VPWR A a_111_343# VPB sky130_fd_pr__pfet_01v8_hvt ad=0.1558 pd=1.33 as=0.10395 ps=1.04 w=0.77 l=0.15
X7 a_291_297# A Y VPB sky130_fd_pr__pfet_01v8_hvt ad=0.26 pd=2.52 as=0.135 ps=1.27 w=1 l=0.15
X8 a_291_297# a_29_343# VPWR VPB sky130_fd_pr__pfet_01v8_hvt ad=0.165 pd=1.33 as=0.1558 ps=1.33 w=1 l=0.15
X9 Y B a_291_297# VPB sky130_fd_pr__pfet_01v8_hvt ad=0.135 pd=1.27 as=0.165 ps=1.33 w=1 l=0.15
C0 VPB A 0.08018f
C1 VPWR Y 0.00224f
C2 a_29_343# a_111_343# 0.00899f
C3 VGND A 0.06826f
C4 VPB VGND 0.0084f
C5 a_29_343# a_291_297# 0.00531f
C6 a_29_343# B 0.16158f
C7 a_291_297# a_387_47# 0
C8 a_387_47# B 0
C9 A a_111_343# 0
C10 VPWR a_29_343# 0.04543f
C11 a_291_297# A 0.06756f
C12 B A 0.20157f
C13 VPB a_291_297# 0.01149f
C14 VPB B 0.08556f
C15 a_291_297# VGND 0.00569f
C16 VPWR A 0.06782f
C17 VGND B 0.06143f
C18 VPWR VPB 0.06948f
C19 VPWR VGND 0.00733f
C20 a_291_297# a_111_343# 0
C21 B a_111_343# 0.00792f
C22 a_291_297# B 0.04072f
C23 VPWR a_111_343# 0.00972f
C24 Y a_29_343# 0.04002f
C25 VPWR a_291_297# 0.08593f
C26 Y a_387_47# 0.0081f
C27 VPWR B 0.06739f
C28 Y A 0.12597f
C29 Y VPB 0.00465f
C30 a_29_343# a_387_47# 0
C31 Y VGND 0.05008f
C32 a_29_343# A 0.12852f
C33 VPB a_29_343# 0.05073f
C34 a_387_47# A 0
C35 a_29_343# VGND 0.08261f
C36 Y a_291_297# 0.02996f
C37 a_387_47# VGND 0.01295f
C38 Y B 0.06747f
C39 VGND VNB 0.59213f
C40 Y VNB 0.1409f
C41 VPWR VNB 0.33043f
C42 VPB VNB 0.60476f
C43 a_291_297# VNB 0.08002f
C44 a_111_343# VNB 0.09822f
.ends
