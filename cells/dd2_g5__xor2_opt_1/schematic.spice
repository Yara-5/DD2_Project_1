* Intended schematic from supplied transistor connections.
* SKY130 model files use um-scale W/L convention; load the course model setup.
.subckt dd2_g5__xor2_opt_1 A B VGND VNB VPB VPWR Y
XN1 n1 A VGND VNB sky130_fd_pr__nfet_01v8 w=0.64 l=0.15
XN2 n1 B VGND VNB sky130_fd_pr__nfet_01v8 w=0.64 l=0.15
XP1 VPWR A n1_u1 VPB sky130_fd_pr__pfet_01v8_hvt w=0.77 l=0.15
XP2 n1_u1 B n1 VPB sky130_fd_pr__pfet_01v8_hvt w=0.77 l=0.15
XN3 Y_d1 A VGND VNB sky130_fd_pr__nfet_01v8 w=0.65 l=0.15
XN4 Y B Y_d1 VNB sky130_fd_pr__nfet_01v8 w=0.65 l=0.15
XN5 Y n1 VGND VNB sky130_fd_pr__nfet_01v8 w=0.65 l=0.15
XP3 Y_u1 A Y VPB sky130_fd_pr__pfet_01v8_hvt w=1 l=0.15
XP4 Y_u1 B Y VPB sky130_fd_pr__pfet_01v8_hvt w=1 l=0.15
XP5 VPWR n1 Y_u1 VPB sky130_fd_pr__pfet_01v8_hvt w=1 l=0.15
.ends dd2_g5__xor2_opt_1
