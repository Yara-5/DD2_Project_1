* NGSPICE file created from dd2_g5__xor2_opt_1.ext - technology: sky130A

.subckt dd2_g5__xor2_opt_1 A B VGND VNB VPB VPWR Y
X0 a_111_343.t1 B.t3 a_29_343.t2 VPB.t2 sky130_fd_pr__pfet_01v8_hvt ad=0.10395 pd=1.04 as=0.2002 ps=2.06 w=0.77 l=0.15
X1 Y.t3 a_29_343.t3 VGND.t3 VNB.t0 sky130_fd_pr__nfet_01v8 ad=0.10725 pd=0.98 as=0.10685 ps=0.98 w=0.65 l=0.15
X2 VGND.t0 A.t1 a_29_343.t0 VNB.t1 sky130_fd_pr__nfet_01v8 ad=0.10685 pd=0.98 as=0.0864 ps=0.91 w=0.64 l=0.15
X3 a_29_343.t1 B.t1 VGND.t2 VNB.t3 sky130_fd_pr__nfet_01v8 ad=0.0864 pd=0.91 as=0.1664 ps=1.8 w=0.64 l=0.15
X4 VGND.t1 A.t0 a_387_47.t0 VNB.t2 sky130_fd_pr__nfet_01v8 ad=0.169 pd=1.82 as=0.08775 ps=0.92 w=0.65 l=0.15
X5 a_387_47.t1 B.t0 Y.t1 VNB.t4 sky130_fd_pr__nfet_01v8 ad=0.08775 pd=0.92 as=0.10725 ps=0.98 w=0.65 l=0.15
X6 VPWR.t0 A.t3 a_111_343.t0 VPB.t0 sky130_fd_pr__pfet_01v8_hvt ad=0.1558 pd=1.33 as=0.10395 ps=1.04 w=0.77 l=0.15
X7 a_291_297.t0 A.t2 Y.t0 VPB.t1 sky130_fd_pr__pfet_01v8_hvt ad=0.26 pd=2.52 as=0.135 ps=1.27 w=1 l=0.15
X8 a_291_297.t2 a_29_343.t4 VPWR.t1 VPB.t4 sky130_fd_pr__pfet_01v8_hvt ad=0.165 pd=1.33 as=0.1558 ps=1.33 w=1 l=0.15
X9 Y.t2 B.t2 a_291_297.t1 VPB.t3 sky130_fd_pr__pfet_01v8_hvt ad=0.135 pd=1.27 as=0.165 ps=1.33 w=1 l=0.15
R0 VGND.n2 VGND.n1 199.739
R1 VGND.n3 VGND.t1 156.828
R2 VGND.n6 VGND.t2 149.734
R3 VGND.n1 VGND.t0 30.938
R4 VGND.n1 VGND.t3 27.7925
R5 VGND.n2 VGND.n0 21.4593
R6 VGND.n6 VGND.n0 19.2005
R7 VGND.n4 VGND.n0 9.3005
R8 VGND.n6 VGND.n5 9.3005
R9 VGND.n3 VGND.n2 7.00743
R10 VGND VGND.n6 3.10353
R11 VGND.n4 VGND.n3 0.251681
R12 VGND.n5 VGND.n4 0.120292
R13 VGND.n5 VGND 0.0239375
R14 Y.n2 Y.n0 604.639
R15 Y.n2 Y.n1 185
R16 Y.n1 Y.t1 30.462
R17 Y.n1 Y.t3 30.462
R18 Y.n0 Y.t0 26.5955
R19 Y.n0 Y.t2 26.5955
R20 Y Y.n2 3.10353
R21 VPWR.n1 VPWR.n0 614.086
R22 VPWR.n0 VPWR.t0 42.2148
R23 VPWR.n0 VPWR.t1 38.0359
R24 VPWR VPWR.n1 14.1071
R25 VPWR.n1 VPWR 0.321295
R26 A.n1 A.t3 278.49
R27 A.n0 A.t2 241.536
R28 A.n2 A.n0 173.034
R29 A.n1 A.t1 170.843
R30 A.n0 A.t0 169.237
R31 A.n2 A.n1 152
R32 A A.n2 3.10353
R33 B.n2 B.n0 282.243
R34 B.n1 B.t3 278.49
R35 B.n0 B.t2 241.536
R36 B.n1 B.t1 170.843
R37 B.n0 B.t0 169.237
R38 B.n2 B.n1 152
R39 B B.n2 3.10353
R40 VPB.t4 VPB.t3 284.113
R41 VPB.t0 VPB.t4 284.113
R42 VPB.t3 VPB.t1 248.599
R43 VPB.t2 VPB.t0 248.599
R44 VPB VPB.t2 201.246
R45 VNB.t0 VNB.t4 1366.99
R46 VNB.t1 VNB.t0 1366.99
R47 VNB.t4 VNB.t2 1196.12
R48 VNB.t3 VNB.t1 1196.12
R49 VNB VNB.t3 968.285
R50 a_387_47.t0 a_387_47.t1 49.8467
R51 a_291_297.t0 a_291_297.n0 866.855
R52 a_291_297.n0 a_291_297.t1 32.5055
R53 a_291_297.n0 a_291_297.t2 32.5055
R54 a_111_343.t0 a_111_343.t1 69.0784
R55 a_29_343.n1 a_29_343.t2 440.635
R56 a_29_343.n2 a_29_343.n1 246.025
R57 a_29_343.n0 a_29_343.t4 241.536
R58 a_29_343.n0 a_29_343.t3 169.237
R59 a_29_343.n1 a_29_343.n0 152
R60 a_29_343.t0 a_29_343.n2 25.313
R61 a_29_343.n2 a_29_343.t1 25.313
C0 B A 0.20157f
C1 B VPWR 0.06739f
C2 Y VPB 0.00465f
C3 VGND Y 0.05008f
C4 B VPB 0.08556f
C5 VGND B 0.06143f
C6 A VPWR 0.06782f
C7 Y B 0.06747f
C8 VPB A 0.08018f
C9 VPB VPWR 0.06948f
C10 VGND A 0.06826f
C11 VGND VPWR 0.00733f
C12 Y A 0.12597f
C13 Y VPWR 0.00224f
C14 VGND VPB 0.0084f
C15 VGND VNB 0.40715f
C16 Y VNB 0.04549f
C17 VPWR VNB 0.50948f
C18 A VNB 0.20136f
C19 B VNB 0.20403f
C20 VPB VNB 0.6542f
C21 a_29_343.t1 VNB 0.04116f
C22 a_29_343.t2 VNB 0.12357f
C23 a_29_343.n0 VNB 0.05671f
C24 a_29_343.n1 VNB 0.20362f
C25 a_29_343.n2 VNB 0.04282f
C26 a_29_343.t0 VNB 0.04244f
C27 a_111_343.t1 VNB 0.04639f
C28 a_111_343.t0 VNB 0.04807f
C29 a_291_297.t1 VNB 0.05494f
C30 a_291_297.t2 VNB 0.04837f
C31 a_291_297.n0 VNB 0.06972f
C32 a_291_297.t0 VNB 0.17428f
C33 a_387_47.t1 VNB 0.03624f
C34 a_387_47.t0 VNB 0.03753f
C35 VPB.t1 VNB 0.08701f
C36 VPB.t3 VNB 0.0445f
C37 VPB.t4 VNB 0.04746f
C38 VPB.t0 VNB 0.0445f
C39 VPB.t2 VNB 0.03757f
C40 B.n0 VNB 0.12007f
C41 B.n1 VNB 0.07411f
C42 B.n2 VNB 0.25658f
C43 A.n0 VNB 0.09397f
C44 A.n1 VNB 0.07788f
C45 A.n2 VNB 0.31278f
C46 VPWR.t1 VNB 0.03744f
C47 VPWR.t0 VNB 0.04488f
C48 VPWR.n0 VNB 0.03196f
C49 VPWR.n1 VNB 0.0765f
C50 Y.t0 VNB 0.06003f
C51 Y.t2 VNB 0.05825f
C52 Y.n0 VNB 0.04931f
C53 Y.t1 VNB 0.04378f
C54 Y.t3 VNB 0.03903f
C55 Y.n1 VNB 0.0371f
C56 Y.n2 VNB 0.15314f
C57 VGND.n0 VNB 0.00463f
C58 VGND.t2 VNB 0.04107f
C59 VGND.t1 VNB 0.04437f
C60 VGND.t3 VNB 0.02312f
C61 VGND.t0 VNB 0.03174f
C62 VGND.n1 VNB 0.01426f
C63 VGND.n2 VNB 0.02441f
C64 VGND.n3 VNB 0.09463f
C65 VGND.n4 VNB 0.06038f
C66 VGND.n5 VNB 0.01331f
C67 VGND.n6 VNB 0.03294f
.ends
