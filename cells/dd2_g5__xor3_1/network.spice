* dd2_g5__xor3_1: Y = (!x1 & !C) | (x1 & C), x1 = (!A & !B) | (A & B)
* Generated by synthesize.py; stages in signal order:
*   x1_n1 = !(A & B)
*   x1 = !((A | B) & x1_n1)
*   n1 = !(x1 & C)
*   Y = !((x1 | C) & n1)
.subckt dd2_g5__xor3_1 A B C VGND VNB VPB VPWR Y
XN1 x1_n1 A x1_n1_d1 VNB sky130_fd_pr__nfet_01v8 w=0.65 l=0.15
XN2 x1_n1_d1 B VGND VNB sky130_fd_pr__nfet_01v8 w=0.65 l=0.15
XP1 x1_n1 A VPWR VPB sky130_fd_pr__pfet_01v8_hvt w=1 l=0.15
XP2 x1_n1 B VPWR VPB sky130_fd_pr__pfet_01v8_hvt w=1 l=0.15
XN3 x1 A x1_d1 VNB sky130_fd_pr__nfet_01v8 w=0.65 l=0.15
XN4 x1 B x1_d1 VNB sky130_fd_pr__nfet_01v8 w=0.65 l=0.15
XN5 x1_d1 x1_n1 VGND VNB sky130_fd_pr__nfet_01v8 w=0.65 l=0.15
XP3 x1_u1 A VPWR VPB sky130_fd_pr__pfet_01v8_hvt w=1 l=0.15
XP4 x1 B x1_u1 VPB sky130_fd_pr__pfet_01v8_hvt w=1 l=0.15
XP5 x1 x1_n1 VPWR VPB sky130_fd_pr__pfet_01v8_hvt w=1 l=0.15
XN6 n1 x1 n1_d1 VNB sky130_fd_pr__nfet_01v8 w=0.65 l=0.15
XN7 n1_d1 C VGND VNB sky130_fd_pr__nfet_01v8 w=0.65 l=0.15
XP6 n1 x1 VPWR VPB sky130_fd_pr__pfet_01v8_hvt w=1 l=0.15
XP7 n1 C VPWR VPB sky130_fd_pr__pfet_01v8_hvt w=1 l=0.15
XN8 Y x1 Y_d1 VNB sky130_fd_pr__nfet_01v8 w=0.65 l=0.15
XN9 Y C Y_d1 VNB sky130_fd_pr__nfet_01v8 w=0.65 l=0.15
XN10 Y_d1 n1 VGND VNB sky130_fd_pr__nfet_01v8 w=0.65 l=0.15
XP8 Y_u1 x1 VPWR VPB sky130_fd_pr__pfet_01v8_hvt w=1 l=0.15
XP9 Y C Y_u1 VPB sky130_fd_pr__pfet_01v8_hvt w=1 l=0.15
XP10 Y n1 VPWR VPB sky130_fd_pr__pfet_01v8_hvt w=1 l=0.15
.ends dd2_g5__xor3_1
