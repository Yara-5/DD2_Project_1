* NGSPICE file created from dd2_g5__xor3_1.ext - technology: sky130A

.subckt dd2_g5__xor3_1 A B C VGND VNB VPB VPWR Y
X0 a_943_47# C VGND VNB sky130_fd_pr__nfet_01v8 ad=0.08775 pd=0.92 as=0.08775 ps=0.92 w=0.65 l=0.15
X1 a_753_47# C a_671_47# VNB sky130_fd_pr__nfet_01v8 ad=0.08775 pd=0.92 as=0.169 ps=1.82 w=0.65 l=0.15
X2 VPWR A a_43_47# VPB sky130_fd_pr__pfet_01v8_hvt ad=0.26 pd=2.52 as=0.135 ps=1.27 w=1 l=0.15
X3 VPWR a_43_47# a_481_297# VPB sky130_fd_pr__pfet_01v8_hvt ad=0.26 pd=2.52 as=0.135 ps=1.27 w=1 l=0.15
X4 VGND A a_125_47# VNB sky130_fd_pr__nfet_01v8 ad=0.169 pd=1.82 as=0.08775 ps=0.92 w=0.65 l=0.15
X5 a_481_297# B a_397_297# VPB sky130_fd_pr__pfet_01v8_hvt ad=0.135 pd=1.27 as=0.135 ps=1.27 w=1 l=0.15
X6 VGND a_481_297# a_753_47# VNB sky130_fd_pr__nfet_01v8 ad=0.169 pd=1.82 as=0.08775 ps=0.92 w=0.65 l=0.15
X7 a_125_47# B a_43_47# VNB sky130_fd_pr__nfet_01v8 ad=0.08775 pd=0.92 as=0.169 ps=1.82 w=0.65 l=0.15
X8 VPWR a_671_47# Y VPB sky130_fd_pr__pfet_01v8_hvt ad=0.26 pd=2.52 as=0.135 ps=1.27 w=1 l=0.15
X9 a_397_297# A VPWR VPB sky130_fd_pr__pfet_01v8_hvt ad=0.135 pd=1.27 as=0.26 ps=2.52 w=1 l=0.15
X10 VPWR a_481_297# a_671_47# VPB sky130_fd_pr__pfet_01v8_hvt ad=0.26 pd=2.52 as=0.135 ps=1.27 w=1 l=0.15
X11 a_315_47# B VGND VNB sky130_fd_pr__nfet_01v8 ad=0.08775 pd=0.92 as=0.08775 ps=0.92 w=0.65 l=0.15
X12 a_1025_297# a_481_297# VPWR VPB sky130_fd_pr__pfet_01v8_hvt ad=0.135 pd=1.27 as=0.26 ps=2.52 w=1 l=0.15
X13 Y C a_1025_297# VPB sky130_fd_pr__pfet_01v8_hvt ad=0.135 pd=1.27 as=0.135 ps=1.27 w=1 l=0.15
X14 a_43_47# B VPWR VPB sky130_fd_pr__pfet_01v8_hvt ad=0.135 pd=1.27 as=0.26 ps=2.52 w=1 l=0.15
X15 a_671_47# C VPWR VPB sky130_fd_pr__pfet_01v8_hvt ad=0.135 pd=1.27 as=0.26 ps=2.52 w=1 l=0.15
X16 Y a_671_47# a_943_47# VNB sky130_fd_pr__nfet_01v8 ad=0.169 pd=1.82 as=0.08775 ps=0.92 w=0.65 l=0.15
X17 VGND A a_315_47# VNB sky130_fd_pr__nfet_01v8 ad=0.08775 pd=0.92 as=0.169 ps=1.82 w=0.65 l=0.15
X18 a_481_297# a_43_47# a_315_47# VNB sky130_fd_pr__nfet_01v8 ad=0.169 pd=1.82 as=0.08775 ps=0.92 w=0.65 l=0.15
X19 VGND a_481_297# a_943_47# VNB sky130_fd_pr__nfet_01v8 ad=0.08775 pd=0.92 as=0.169 ps=1.82 w=0.65 l=0.15
C0 a_671_47# a_481_297# 0.17207f
C1 a_43_47# B 0.2125f
C2 Y a_1025_297# 0.00801f
C3 VGND a_315_47# 0.06218f
C4 a_315_47# B 0.02874f
C5 VPB a_43_47# 0.06156f
C6 a_43_47# VPWR 0.29372f
C7 VGND Y 0.04829f
C8 a_397_297# a_43_47# 0.00598f
C9 a_671_47# a_943_47# 0.01194f
C10 a_43_47# C 0.04092f
C11 a_315_47# VPB 0.00225f
C12 a_315_47# VPWR 0.00688f
C13 a_43_47# a_481_297# 0.16185f
C14 a_1025_297# VPWR 0.01562f
C15 a_315_47# a_397_297# 0.00317f
C16 VGND B 0.06289f
C17 a_315_47# a_481_297# 0.03473f
C18 a_1025_297# C 0.00226f
C19 A a_125_47# 0
C20 Y VPB 0.00431f
C21 Y VPWR 0.08041f
C22 VGND VPB 0.01435f
C23 VGND VPWR 0.01075f
C24 Y C 0.05362f
C25 Y a_481_297# 0.01253f
C26 a_671_47# a_753_47# 0.00972f
C27 VGND C 0.0485f
C28 VPB B 0.06547f
C29 VPWR B 0.06169f
C30 VGND a_481_297# 0.12669f
C31 a_397_297# B 0.00226f
C32 a_1025_297# a_943_47# 0.00317f
C33 a_481_297# B 0.0538f
C34 a_671_47# A 0
C35 VPB VPWR 0.24634f
C36 VPB C 0.06592f
C37 Y a_943_47# 0.03473f
C38 a_397_297# VPWR 0.01562f
C39 VPWR C 0.06217f
C40 VPB a_481_297# 0.09536f
C41 a_753_47# a_43_47# 0
C42 a_481_297# VPWR 0.13224f
C43 VGND a_943_47# 0.06202f
C44 a_397_297# a_481_297# 0.00801f
C45 a_481_297# C 0.15236f
C46 A a_43_47# 0.09758f
C47 a_43_47# a_125_47# 0.00972f
C48 VPB a_943_47# 0.00225f
C49 a_315_47# A 0.01955f
C50 a_943_47# VPWR 0.00688f
C51 a_315_47# a_125_47# 0
C52 Y a_753_47# 0
C53 a_943_47# C 0.02874f
C54 VGND a_753_47# 0.00627f
C55 a_943_47# a_481_297# 0.02333f
C56 a_671_47# a_43_47# 0.01052f
C57 VGND A 0.03646f
C58 VGND a_125_47# 0.00642f
C59 a_315_47# a_671_47# 0
C60 A B 0.10725f
C61 a_125_47# B 0.00149f
C62 a_1025_297# a_671_47# 0.00598f
C63 a_753_47# C 0
C64 a_753_47# a_481_297# 0.00288f
C65 VPB A 0.08835f
C66 Y a_671_47# 0.15686f
C67 A VPWR 0.04723f
C68 VGND a_671_47# 0.0755f
C69 A a_481_297# 0.00719f
C70 a_481_297# a_125_47# 0
C71 a_315_47# a_43_47# 0.01194f
C72 a_671_47# B 0
C73 a_1025_297# a_43_47# 0
C74 a_753_47# a_943_47# 0
C75 a_671_47# VPB 0.0612f
C76 Y a_43_47# 0.00117f
C77 a_671_47# VPWR 0.28773f
C78 VGND a_43_47# 0.08178f
C79 a_671_47# a_397_297# 0
C80 a_671_47# C 0.20534f
C81 VGND VNB 0.98509f
C82 Y VNB 0.12748f
C83 VPWR VNB 0.90273f
C84 VPB VNB 1.31353f
C85 a_943_47# VNB 0.06892f
C86 a_753_47# VNB 0.19329f
C87 a_315_47# VNB 0.00619f
C88 a_397_297# VNB 0.08779f
.ends
