* NGSPICE file created from dd2_g5__xor3_1.ext - technology: sky130A

.subckt dd2_g5__xor3_1 A B C VGND VNB VPB VPWR Y
X0 VGND A a_591_47# VNB sky130_fd_pr__nfet_01v8 ad=0.17225 pd=1.18 as=0.10075 ps=0.96 w=0.65 l=0.15
X1 Y a_819_297# a_1061_47# VNB sky130_fd_pr__nfet_01v8 ad=0.169 pd=1.82 as=0.17225 ps=1.18 w=0.65 l=0.15
X2 a_819_47# a_267_297# VGND VNB sky130_fd_pr__nfet_01v8 ad=0.17225 pd=1.18 as=0.17225 ps=1.18 w=0.65 l=0.15
X3 VPWR a_819_297# Y VPB sky130_fd_pr__pfet_01v8_hvt ad=0.26 pd=2.52 as=0.265 ps=1.53 w=1 l=0.15
X4 Y C a_1143_297# VPB sky130_fd_pr__pfet_01v8_hvt ad=0.265 pd=1.53 as=0.155 ps=1.31 w=1 l=0.15
X5 a_267_297# a_363_199# a_49_47# VNB sky130_fd_pr__nfet_01v8 ad=0.169 pd=1.82 as=0.17225 ps=1.18 w=0.65 l=0.15
X6 VPWR A a_363_199# VPB sky130_fd_pr__pfet_01v8_hvt ad=0.265 pd=1.53 as=0.155 ps=1.31 w=1 l=0.15
X7 a_819_297# a_267_297# VPWR VPB sky130_fd_pr__pfet_01v8_hvt ad=0.265 pd=1.53 as=0.265 ps=1.53 w=1 l=0.15
X8 a_1061_47# C VGND VNB sky130_fd_pr__nfet_01v8 ad=0.17225 pd=1.18 as=0.10075 ps=0.96 w=0.65 l=0.15
X9 VPWR C a_819_297# VPB sky130_fd_pr__pfet_01v8_hvt ad=0.26 pd=2.52 as=0.265 ps=1.53 w=1 l=0.15
X10 VGND A a_49_47# VNB sky130_fd_pr__nfet_01v8 ad=0.17225 pd=1.18 as=0.169 ps=1.82 w=0.65 l=0.15
X11 a_591_47# B a_363_199# VNB sky130_fd_pr__nfet_01v8 ad=0.10075 pd=0.96 as=0.169 ps=1.82 w=0.65 l=0.15
X12 a_49_47# B VGND VNB sky130_fd_pr__nfet_01v8 ad=0.17225 pd=1.18 as=0.17225 ps=1.18 w=0.65 l=0.15
X13 VPWR a_363_199# a_267_297# VPB sky130_fd_pr__pfet_01v8_hvt ad=0.26 pd=2.52 as=0.265 ps=1.53 w=1 l=0.15
X14 a_131_297# A VPWR VPB sky130_fd_pr__pfet_01v8_hvt ad=0.265 pd=1.53 as=0.26 ps=2.52 w=1 l=0.15
X15 a_267_297# B a_131_297# VPB sky130_fd_pr__pfet_01v8_hvt ad=0.265 pd=1.53 as=0.265 ps=1.53 w=1 l=0.15
X16 a_819_297# C a_819_47# VNB sky130_fd_pr__nfet_01v8 ad=0.169 pd=1.82 as=0.17225 ps=1.18 w=0.65 l=0.15
X17 a_1143_297# a_267_297# VPWR VPB sky130_fd_pr__pfet_01v8_hvt ad=0.155 pd=1.31 as=0.26 ps=2.52 w=1 l=0.15
X18 a_363_199# B VPWR VPB sky130_fd_pr__pfet_01v8_hvt ad=0.155 pd=1.31 as=0.26 ps=2.52 w=1 l=0.15
X19 VGND a_267_297# a_1061_47# VNB sky130_fd_pr__nfet_01v8 ad=0.10075 pd=0.96 as=0.169 ps=1.82 w=0.65 l=0.15
C0 C a_819_297# 0.10938f
C1 a_131_297# VPWR 0.02391f
C2 VPWR a_1061_47# 0.00185f
C3 a_1143_297# Y 0.0012f
C4 VPB a_267_297# 0.09435f
C5 A VPWR 0.20945f
C6 a_819_47# a_363_199# 0
C7 VGND VPWR 0.03162f
C8 VGND a_819_47# 0.01474f
C9 a_267_297# a_591_47# 0.00559f
C10 a_131_297# a_363_199# 0
C11 a_819_297# a_49_47# 0
C12 a_1143_297# C 0.00959f
C13 A a_363_199# 0.12327f
C14 VGND a_363_199# 0.03446f
C15 A a_131_297# 0.02621f
C16 a_1143_297# a_819_297# 0.00337f
C17 VPWR B 0.02989f
C18 VGND a_131_297# 0.00351f
C19 VGND a_1061_47# 0.07026f
C20 a_267_297# Y 0.00112f
C21 VGND A 0.03486f
C22 VPWR VPB 0.24567f
C23 a_363_199# B 0.15746f
C24 VPWR a_591_47# 0
C25 a_131_297# B 0
C26 C a_267_297# 0.14466f
C27 A B 0.11116f
C28 VPB a_363_199# 0.0508f
C29 VGND B 0.02594f
C30 a_267_297# a_819_297# 0.12786f
C31 VPB a_1061_47# 0.00148f
C32 A VPB 0.11555f
C33 VPWR Y 0.05051f
C34 VGND VPB 0.01171f
C35 a_363_199# a_591_47# 0.00685f
C36 a_267_297# a_49_47# 0.04405f
C37 A a_591_47# 0
C38 a_1143_297# a_267_297# 0
C39 VGND a_591_47# 0.00835f
C40 VPWR C 0.07224f
C41 VPB B 0.07733f
C42 Y a_1061_47# 0.0131f
C43 VPWR a_819_297# 0.06732f
C44 A Y 0.00113f
C45 VGND Y 0.02044f
C46 a_819_47# a_819_297# 0.01404f
C47 C a_363_199# 0
C48 VPWR a_49_47# 0.00555f
C49 C a_1061_47# 0.02491f
C50 a_819_297# a_363_199# 0.00132f
C51 A C 0.00136f
C52 a_1143_297# VPWR 0.01397f
C53 VGND C 0.02619f
C54 a_819_297# a_1061_47# 0.06587f
C55 A a_819_297# 0.01391f
C56 VGND a_819_297# 0.11351f
C57 a_363_199# a_49_47# 0.00106f
C58 a_131_297# a_49_47# 0
C59 VPB Y 0.01493f
C60 A a_49_47# 0.03231f
C61 VGND a_49_47# 0.08347f
C62 C B 0
C63 a_1143_297# a_1061_47# 0
C64 A a_1143_297# 0
C65 a_819_297# B 0
C66 VPB C 0.08146f
C67 VPWR a_267_297# 0.11239f
C68 VPB a_819_297# 0.04684f
C69 a_819_47# a_267_297# 0.00662f
C70 B a_49_47# 0.03002f
C71 a_267_297# a_363_199# 0.1073f
C72 VPB a_49_47# 0.00108f
C73 a_819_297# a_591_47# 0
C74 a_131_297# a_267_297# 0.00117f
C75 a_267_297# a_1061_47# 0.02474f
C76 A a_267_297# 0.16236f
C77 C Y 0.01181f
C78 VGND a_267_297# 0.19404f
C79 a_819_297# Y 0.06618f
C80 a_819_47# VPWR 0
C81 a_267_297# B 0.1387f
C82 VPWR a_363_199# 0.04665f
C83 VGND VNB 1.02692f
C84 Y VNB 0.19599f
C85 VPWR VNB 0.74668f
C86 VPB VNB 1.49072f
C87 a_1061_47# VNB 0.07381f
C88 a_819_47# VNB 0.10617f
C89 a_591_47# VNB 0.1781f
C90 a_49_47# VNB 0.0613f
C91 a_1143_297# VNB 0.08915f
C92 a_819_297# VNB 0.02065f
.ends
