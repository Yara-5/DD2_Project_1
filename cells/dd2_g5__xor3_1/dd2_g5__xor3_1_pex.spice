* NGSPICE file created from dd2_g5__xor3_1.ext - technology: sky130A

.subckt dd2_g5__xor3_1 A B C VGND VNB VPB VPWR Y
X0 VGND.t0 A.t0 a_591_47.t0 VNB.t1 sky130_fd_pr__nfet_01v8 ad=0.17225 pd=1.18 as=0.10075 ps=0.96 w=0.65 l=0.15
X1 Y.t1 a_819_297.t3 a_1061_47.t1 VNB.t5 sky130_fd_pr__nfet_01v8 ad=0.169 pd=1.82 as=0.17225 ps=1.18 w=0.65 l=0.15
X2 a_819_47.t0 a_267_297.t4 VGND.t4 VNB.t2 sky130_fd_pr__nfet_01v8 ad=0.17225 pd=1.18 as=0.17225 ps=1.18 w=0.65 l=0.15
X3 VPWR.t6 a_819_297.t4 Y.t2 VPB.t5 sky130_fd_pr__pfet_01v8_hvt ad=0.26 pd=2.52 as=0.265 ps=1.53 w=1 l=0.15
X4 Y.t0 C.t2 a_1143_297.t1 VPB.t7 sky130_fd_pr__pfet_01v8_hvt ad=0.265 pd=1.53 as=0.155 ps=1.31 w=1 l=0.15
X5 a_267_297.t0 a_363_199.t3 a_49_47.t1 VNB.t4 sky130_fd_pr__nfet_01v8 ad=0.169 pd=1.82 as=0.17225 ps=1.18 w=0.65 l=0.15
X6 VPWR.t1 A.t2 a_363_199.t0 VPB.t1 sky130_fd_pr__pfet_01v8_hvt ad=0.265 pd=1.53 as=0.155 ps=1.31 w=1 l=0.15
X7 a_819_297.t0 a_267_297.t6 VPWR.t4 VPB.t3 sky130_fd_pr__pfet_01v8_hvt ad=0.265 pd=1.53 as=0.265 ps=1.53 w=1 l=0.15
X8 a_1061_47.t2 C.t0 VGND.t2 VNB.t7 sky130_fd_pr__nfet_01v8 ad=0.17225 pd=1.18 as=0.10075 ps=0.96 w=0.65 l=0.15
X9 VPWR.t2 C.t3 a_819_297.t1 VPB.t6 sky130_fd_pr__pfet_01v8_hvt ad=0.26 pd=2.52 as=0.265 ps=1.53 w=1 l=0.15
X10 VGND.t1 A.t1 a_49_47.t0 VNB.t0 sky130_fd_pr__nfet_01v8 ad=0.17225 pd=1.18 as=0.169 ps=1.82 w=0.65 l=0.15
X11 a_591_47.t1 B.t0 a_363_199.t2 VNB.t9 sky130_fd_pr__nfet_01v8 ad=0.10075 pd=0.96 as=0.169 ps=1.82 w=0.65 l=0.15
X12 a_49_47.t2 B.t1 VGND.t3 VNB.t8 sky130_fd_pr__nfet_01v8 ad=0.17225 pd=1.18 as=0.17225 ps=1.18 w=0.65 l=0.15
X13 VPWR.t5 a_363_199.t4 a_267_297.t1 VPB.t4 sky130_fd_pr__pfet_01v8_hvt ad=0.26 pd=2.52 as=0.265 ps=1.53 w=1 l=0.15
X14 a_131_297.t0 A.t3 VPWR.t0 VPB.t0 sky130_fd_pr__pfet_01v8_hvt ad=0.265 pd=1.53 as=0.26 ps=2.52 w=1 l=0.15
X15 a_267_297.t2 B.t3 a_131_297.t1 VPB.t8 sky130_fd_pr__pfet_01v8_hvt ad=0.265 pd=1.53 as=0.265 ps=1.53 w=1 l=0.15
X16 a_819_297.t2 C.t1 a_819_47.t1 VNB.t6 sky130_fd_pr__nfet_01v8 ad=0.169 pd=1.82 as=0.17225 ps=1.18 w=0.65 l=0.15
X17 a_1143_297.t0 a_267_297.t5 VPWR.t3 VPB.t2 sky130_fd_pr__pfet_01v8_hvt ad=0.155 pd=1.31 as=0.26 ps=2.52 w=1 l=0.15
X18 a_363_199.t1 B.t2 VPWR.t7 VPB.t9 sky130_fd_pr__pfet_01v8_hvt ad=0.155 pd=1.31 as=0.26 ps=2.52 w=1 l=0.15
X19 VGND.t5 a_267_297.t3 a_1061_47.t0 VNB.t3 sky130_fd_pr__nfet_01v8 ad=0.10075 pd=0.96 as=0.169 ps=1.82 w=0.65 l=0.15
R0 VGND.n5 VGND.n4 205.672
R1 VGND.n16 VGND.n15 199.739
R2 VGND.n7 VGND.n6 199.739
R3 VGND.n15 VGND.t1 48.9236
R4 VGND.n15 VGND.t3 48.9236
R5 VGND.n6 VGND.t0 48.9236
R6 VGND.n6 VGND.t4 48.9236
R7 VGND.n21 VGND.n0 34.6358
R8 VGND.n17 VGND.n14 34.6358
R9 VGND.n14 VGND.n13 34.6358
R10 VGND.n13 VGND.n2 34.6358
R11 VGND.n9 VGND.n2 34.6358
R12 VGND.n9 VGND.n8 34.6358
R13 VGND.n4 VGND.t5 28.6159
R14 VGND.n4 VGND.t2 28.6159
R15 VGND.n7 VGND.n5 12.4878
R16 VGND.n18 VGND.n17 9.3005
R17 VGND.n14 VGND.n1 9.3005
R18 VGND.n13 VGND.n12 9.3005
R19 VGND.n11 VGND.n2 9.3005
R20 VGND.n10 VGND.n9 9.3005
R21 VGND.n8 VGND.n3 9.3005
R22 VGND.n19 VGND.n0 9.3005
R23 VGND.n21 VGND.n20 9.3005
R24 VGND VGND.n21 6.77697
R25 VGND.n16 VGND.n0 4.89462
R26 VGND.n17 VGND.n16 4.89462
R27 VGND.n8 VGND.n7 4.89462
R28 VGND.n5 VGND.n3 0.154605
R29 VGND.n20 VGND.n19 0.120292
R30 VGND.n19 VGND.n18 0.120292
R31 VGND.n18 VGND.n1 0.120292
R32 VGND.n12 VGND.n1 0.120292
R33 VGND.n12 VGND.n11 0.120292
R34 VGND.n11 VGND.n10 0.120292
R35 VGND.n10 VGND.n3 0.120292
R36 VGND.n20 VGND 0.0239375
R37 Y.n1 Y.n0 693.688
R38 Y.n1 Y.t1 209.923
R39 Y.n0 Y.t2 52.2055
R40 Y.n0 Y.t0 52.2055
R41 Y.n2 Y 6.4005
R42 Y Y.n2 3.2005
R43 Y.n2 Y.n1 0.213833
R44 VPWR.n8 VPWR.t6 888.529
R45 VPWR.n9 VPWR.t3 876.193
R46 VPWR.n7 VPWR.t2 876.193
R47 VPWR.n20 VPWR.t7 876.193
R48 VPWR.n21 VPWR.t5 876.193
R49 VPWR VPWR.t0 875.817
R50 VPWR.n5 VPWR.n4 607.212
R51 VPWR.n4 VPWR.t1 52.2055
R52 VPWR.n4 VPWR.t4 52.2055
R53 VPWR.n28 VPWR.n27 34.6358
R54 VPWR.n27 VPWR.n26 34.6358
R55 VPWR.n26 VPWR.n2 34.6358
R56 VPWR.n19 VPWR.n18 34.6358
R57 VPWR.n15 VPWR.n14 34.6358
R58 VPWR.n14 VPWR.n13 34.6358
R59 VPWR.n9 VPWR.n8 31.5836
R60 VPWR.n22 VPWR.n21 28.6123
R61 VPWR.n10 VPWR.n7 28.6123
R62 VPWR.n28 VPWR.n0 24.0946
R63 VPWR.n20 VPWR.n19 24.0946
R64 VPWR.n18 VPWR.n5 17.3181
R65 VPWR.n15 VPWR.n5 17.3181
R66 VPWR.n31 VPWR.n0 10.5417
R67 VPWR.n22 VPWR.n20 10.5417
R68 VPWR.n10 VPWR.n9 10.5417
R69 VPWR.n31 VPWR.n30 9.3005
R70 VPWR.n29 VPWR.n28 9.3005
R71 VPWR.n27 VPWR.n1 9.3005
R72 VPWR.n26 VPWR.n25 9.3005
R73 VPWR.n24 VPWR.n2 9.3005
R74 VPWR.n23 VPWR.n22 9.3005
R75 VPWR.n19 VPWR.n3 9.3005
R76 VPWR.n18 VPWR.n17 9.3005
R77 VPWR.n16 VPWR.n15 9.3005
R78 VPWR.n14 VPWR.n6 9.3005
R79 VPWR.n13 VPWR.n12 9.3005
R80 VPWR.n11 VPWR.n10 9.3005
R81 VPWR VPWR.n31 6.77697
R82 VPWR.n21 VPWR.n2 6.02403
R83 VPWR.n13 VPWR.n7 6.02403
R84 VPWR.n0 VPWR 0.376971
R85 VPWR.n11 VPWR.n8 0.258869
R86 VPWR.n30 VPWR.n29 0.120292
R87 VPWR.n29 VPWR.n1 0.120292
R88 VPWR.n25 VPWR.n1 0.120292
R89 VPWR.n25 VPWR.n24 0.120292
R90 VPWR.n24 VPWR.n23 0.120292
R91 VPWR.n23 VPWR.n3 0.120292
R92 VPWR.n17 VPWR.n3 0.120292
R93 VPWR.n17 VPWR.n16 0.120292
R94 VPWR.n16 VPWR.n6 0.120292
R95 VPWR.n12 VPWR.n6 0.120292
R96 VPWR.n12 VPWR.n11 0.120292
R97 VPWR.n30 VPWR 0.0239375
R98 C.n2 C.n0 285.497
R99 C.n1 C.t3 241.536
R100 C.n0 C.t2 241.536
R101 C.n1 C.t1 169.237
R102 C.n0 C.t0 169.237
R103 C.n2 C.n1 152
R104 C C.n2 4.0965
R105 B.n1 B.t3 241.536
R106 B.n0 B.t2 229.754
R107 B.n2 B.n0 223.78
R108 B.n1 B.t1 169.237
R109 B.n0 B.t0 157.453
R110 B.n2 B.n1 152
R111 B B.n2 6.02403
R112 A.n2 A.n0 409.663
R113 A.n1 A.t3 241.536
R114 A.n0 A.t2 241.536
R115 A.n1 A.t1 169.237
R116 A.n0 A.t0 169.237
R117 A.n2 A.n1 152
R118 A A.n2 4.0965
R119 VPB.t4 VPB.t9 556.386
R120 VPB.t6 VPB.t2 556.386
R121 VPB.t0 VPB.t8 402.493
R122 VPB.t8 VPB.t4 402.493
R123 VPB.t1 VPB.t3 402.493
R124 VPB.t3 VPB.t6 402.493
R125 VPB.t7 VPB.t5 402.493
R126 VPB.t9 VPB.t1 272.274
R127 VPB.t2 VPB.t7 272.274
R128 VPB VPB.t0 260.437
R129 VNB.t4 VNB.t9 2677.02
R130 VNB.t6 VNB.t3 2677.02
R131 VNB.t0 VNB.t8 1936.57
R132 VNB.t8 VNB.t4 1936.57
R133 VNB.t1 VNB.t2 1936.57
R134 VNB.t2 VNB.t6 1936.57
R135 VNB.t7 VNB.t5 1936.57
R136 VNB.t9 VNB.t1 1310.03
R137 VNB.t3 VNB.t7 1310.03
R138 VNB VNB.t0 1253.07
R139 a_1061_47.t0 a_1061_47.n0 467.106
R140 a_1061_47.n0 a_1061_47.t1 48.9236
R141 a_1061_47.n0 a_1061_47.t2 48.9236
R142 a_819_47.t0 a_819_47.t1 97.8467
R143 a_591_47.t0 a_591_47.t1 57.2313
R144 a_49_47.t0 a_49_47.n0 473.908
R145 a_49_47.n0 a_49_47.t1 48.9236
R146 a_49_47.n0 a_49_47.t2 48.9236
R147 a_1143_297.t0 a_1143_297.t1 61.0705
R148 a_131_297.t0 a_131_297.t1 104.41
R149 a_819_297.n2 a_819_297.n1 688.907
R150 a_819_297.n0 a_819_297.t4 241.536
R151 a_819_297.n1 a_819_297.t2 209.923
R152 a_819_297.n1 a_819_297.n0 204.51
R153 a_819_297.n0 a_819_297.t3 169.237
R154 a_819_297.n2 a_819_297.t1 52.2055
R155 a_819_297.t0 a_819_297.n2 52.2055
R156 a_267_297.n4 a_267_297.n3 600.881
R157 a_267_297.n1 a_267_297.t6 241.536
R158 a_267_297.n0 a_267_297.t5 229.754
R159 a_267_297.n3 a_267_297.t0 219.716
R160 a_267_297.n2 a_267_297.n0 174.269
R161 a_267_297.n1 a_267_297.t4 169.237
R162 a_267_297.n0 a_267_297.t3 157.453
R163 a_267_297.n2 a_267_297.n1 152
R164 a_267_297.n3 a_267_297.n2 88.0696
R165 a_267_297.n4 a_267_297.t2 52.2055
R166 a_267_297.t1 a_267_297.n4 52.2055
R167 a_363_199.n2 a_363_199.n1 594.413
R168 a_363_199.n1 a_363_199.t2 274.998
R169 a_363_199.n1 a_363_199.n0 255.154
R170 a_363_199.n0 a_363_199.t4 241.536
R171 a_363_199.n0 a_363_199.t3 169.237
R172 a_363_199.t0 a_363_199.n2 30.5355
R173 a_363_199.n2 a_363_199.t1 30.5355
C0 VGND B 0.02594f
C1 VPB B 0.07733f
C2 VPWR B 0.02989f
C3 C VGND 0.02619f
C4 C VPB 0.08146f
C5 C VPWR 0.07224f
C6 A VGND 0.03486f
C7 C Y 0.01181f
C8 A VPB 0.11555f
C9 VPWR A 0.20945f
C10 Y A 0.00113f
C11 VGND VPB 0.01171f
C12 VPWR VGND 0.03162f
C13 C B 0
C14 VPWR VPB 0.24567f
C15 Y VGND 0.02044f
C16 Y VPB 0.01493f
C17 Y VPWR 0.05051f
C18 A B 0.11116f
C19 C A 0.00136f
C20 VGND VNB 0.84958f
C21 Y VNB 0.06027f
C22 VPWR VNB 0.69378f
C23 C VNB 0.1434f
C24 B VNB 0.16482f
C25 A VNB 0.20186f
C26 VPB VNB 1.54339f
C27 a_363_199.t1 VNB 0.05955f
C28 a_363_199.t2 VNB 0.09299f
C29 a_363_199.n0 VNB 0.07683f
C30 a_363_199.n1 VNB 0.17857f
C31 a_363_199.n2 VNB 0.05549f
C32 a_363_199.t0 VNB 0.05913f
C33 a_267_297.t2 VNB 0.08181f
C34 a_267_297.n0 VNB 0.09215f
C35 a_267_297.n1 VNB 0.05703f
C36 a_267_297.n2 VNB 0.19142f
C37 a_267_297.t0 VNB 0.07911f
C38 a_267_297.n3 VNB 0.37178f
C39 a_267_297.n4 VNB 0.09947f
C40 a_267_297.t1 VNB 0.07661f
C41 a_819_297.t1 VNB 0.07074f
C42 a_819_297.n0 VNB 0.06603f
C43 a_819_297.t2 VNB 0.06977f
C44 a_819_297.n1 VNB 0.25455f
C45 a_819_297.n2 VNB 0.09183f
C46 a_819_297.t0 VNB 0.07078f
C47 a_131_297.t1 VNB 0.05984f
C48 a_131_297.t0 VNB 0.05896f
C49 a_1143_297.t1 VNB 0.04302f
C50 a_1143_297.t0 VNB 0.04268f
C51 a_49_47.t1 VNB 0.04058f
C52 a_49_47.t2 VNB 0.04434f
C53 a_49_47.n0 VNB 0.08105f
C54 a_49_47.t0 VNB 0.0975f
C55 a_591_47.t1 VNB 0.0338f
C56 a_591_47.t0 VNB 0.03353f
C57 a_819_47.t1 VNB 0.03885f
C58 a_819_47.t0 VNB 0.03889f
C59 a_1061_47.t1 VNB 0.04026f
C60 a_1061_47.t2 VNB 0.04319f
C61 a_1061_47.n0 VNB 0.08232f
C62 a_1061_47.t0 VNB 0.09494f
C63 VPB.t5 VNB 0.10629f
C64 VPB.t7 VNB 0.05458f
C65 VPB.t2 VNB 0.06703f
C66 VPB.t6 VNB 0.07757f
C67 VPB.t3 VNB 0.06512f
C68 VPB.t1 VNB 0.05458f
C69 VPB.t9 VNB 0.06703f
C70 VPB.t4 VNB 0.07757f
C71 VPB.t8 VNB 0.06512f
C72 VPB.t0 VNB 0.05363f
C73 A.n0 VNB 0.22359f
C74 A.n1 VNB 0.06312f
C75 A.n2 VNB 0.32403f
C76 B.n0 VNB 0.12257f
C77 B.n1 VNB 0.06487f
C78 B.n2 VNB 0.15845f
C79 C.n0 VNB 0.09172f
C80 C.n1 VNB 0.05693f
C81 C.n2 VNB 0.13285f
C82 VPWR.t0 VNB 0.06047f
C83 VPWR.n0 VNB 0.00486f
C84 VPWR.n1 VNB 0.02713f
C85 VPWR.n2 VNB 0.00564f
C86 VPWR.n3 VNB 0.02713f
C87 VPWR.t7 VNB 0.06091f
C88 VPWR.t4 VNB 0.04476f
C89 VPWR.t1 VNB 0.04781f
C90 VPWR.n4 VNB 0.0328f
C91 VPWR.n5 VNB 0.01417f
C92 VPWR.n6 VNB 0.02713f
C93 VPWR.t2 VNB 0.05739f
C94 VPWR.n7 VNB 0.01741f
C95 VPWR.t6 VNB 0.05367f
C96 VPWR.n8 VNB 0.10347f
C97 VPWR.t3 VNB 0.05704f
C98 VPWR.n9 VNB 0.01976f
C99 VPWR.n10 VNB 0.00543f
C100 VPWR.n11 VNB 0.07908f
C101 VPWR.n12 VNB 0.02713f
C102 VPWR.n13 VNB 0.00564f
C103 VPWR.n14 VNB 0.00961f
C104 VPWR.n15 VNB 0.00721f
C105 VPWR.n16 VNB 0.02713f
C106 VPWR.n17 VNB 0.02713f
C107 VPWR.n18 VNB 0.00721f
C108 VPWR.n19 VNB 0.00815f
C109 VPWR.n20 VNB 0.01741f
C110 VPWR.t5 VNB 0.05615f
C111 VPWR.n21 VNB 0.01741f
C112 VPWR.n22 VNB 0.00543f
C113 VPWR.n23 VNB 0.02713f
C114 VPWR.n24 VNB 0.02713f
C115 VPWR.n25 VNB 0.02713f
C116 VPWR.n26 VNB 0.00961f
C117 VPWR.n27 VNB 0.00961f
C118 VPWR.n28 VNB 0.00815f
C119 VPWR.n29 VNB 0.02713f
C120 VPWR.n30 VNB 0.01622f
C121 VPWR.n31 VNB 0.0024f
C122 Y.t2 VNB 0.04687f
C123 Y.t0 VNB 0.05093f
C124 Y.n0 VNB 0.04959f
C125 Y.t1 VNB 0.04379f
C126 Y.n1 VNB 0.05493f
C127 Y.n2 VNB 0.00543f
C128 VGND.n0 VNB 0.00496f
C129 VGND.n1 VNB 0.02456f
C130 VGND.n2 VNB 0.0087f
C131 VGND.n3 VNB 0.04044f
C132 VGND.t2 VNB 0.02616f
C133 VGND.t5 VNB 0.02587f
C134 VGND.n4 VNB 0.01318f
C135 VGND.n5 VNB 0.2543f
C136 VGND.t4 VNB 0.03017f
C137 VGND.t0 VNB 0.03237f
C138 VGND.n6 VNB 0.01991f
C139 VGND.n7 VNB 0.02483f
C140 VGND.n8 VNB 0.00496f
C141 VGND.n9 VNB 0.0087f
C142 VGND.n10 VNB 0.02456f
C143 VGND.n11 VNB 0.02456f
C144 VGND.n12 VNB 0.02456f
C145 VGND.n13 VNB 0.0087f
C146 VGND.n14 VNB 0.0087f
C147 VGND.t3 VNB 0.033f
C148 VGND.t1 VNB 0.03237f
C149 VGND.n15 VNB 0.01991f
C150 VGND.n16 VNB 0.02067f
C151 VGND.n17 VNB 0.00496f
C152 VGND.n18 VNB 0.02456f
C153 VGND.n19 VNB 0.02456f
C154 VGND.n20 VNB 0.01468f
C155 VGND.n21 VNB 0.0052f
.ends
