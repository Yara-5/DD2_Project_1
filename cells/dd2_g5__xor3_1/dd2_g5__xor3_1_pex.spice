* NGSPICE file created from dd2_g5__xor3_1.ext - technology: sky130A

.subckt dd2_g5__xor3_1 A B C VGND VNB VPB VPWR Y
X0 a_943_47.t2 C.t0 VGND.t0 VNB.t7 sky130_fd_pr__nfet_01v8 ad=0.08775 pd=0.92 as=0.08775 ps=0.92 w=0.65 l=0.15
X1 a_753_47.t1 C.t1 a_671_47.t2 VNB.t6 sky130_fd_pr__nfet_01v8 ad=0.08775 pd=0.92 as=0.169 ps=1.82 w=0.65 l=0.15
X2 VPWR.t7 A.t3 a_43_47.t2 VPB.t8 sky130_fd_pr__pfet_01v8_hvt ad=0.26 pd=2.52 as=0.135 ps=1.27 w=1 l=0.15
X3 VPWR.t5 a_43_47.t4 a_481_297.t2 VPB.t5 sky130_fd_pr__pfet_01v8_hvt ad=0.26 pd=2.52 as=0.135 ps=1.27 w=1 l=0.15
X4 VGND.t4 A.t1 a_125_47.t1 VNB.t8 sky130_fd_pr__nfet_01v8 ad=0.169 pd=1.82 as=0.08775 ps=0.92 w=0.65 l=0.15
X5 a_481_297.t0 B.t2 a_397_297.t0 VPB.t1 sky130_fd_pr__pfet_01v8_hvt ad=0.135 pd=1.27 as=0.135 ps=1.27 w=1 l=0.15
X6 VGND.t5 a_481_297.t4 a_753_47.t0 VNB.t5 sky130_fd_pr__nfet_01v8 ad=0.169 pd=1.82 as=0.08775 ps=0.92 w=0.65 l=0.15
X7 a_125_47.t0 B.t1 a_43_47.t1 VNB.t0 sky130_fd_pr__nfet_01v8 ad=0.08775 pd=0.92 as=0.169 ps=1.82 w=0.65 l=0.15
X8 VPWR.t1 a_671_47.t4 Y.t1 VPB.t2 sky130_fd_pr__pfet_01v8_hvt ad=0.26 pd=2.52 as=0.135 ps=1.27 w=1 l=0.15
X9 a_397_297.t1 A.t2 VPWR.t6 VPB.t9 sky130_fd_pr__pfet_01v8_hvt ad=0.135 pd=1.27 as=0.26 ps=2.52 w=1 l=0.15
X10 VPWR.t4 a_481_297.t6 a_671_47.t0 VPB.t4 sky130_fd_pr__pfet_01v8_hvt ad=0.26 pd=2.52 as=0.135 ps=1.27 w=1 l=0.15
X11 a_315_47.t0 B.t0 VGND.t2 VNB.t1 sky130_fd_pr__nfet_01v8 ad=0.08775 pd=0.92 as=0.08775 ps=0.92 w=0.65 l=0.15
X12 a_1025_297.t0 a_481_297.t5 VPWR.t3 VPB.t3 sky130_fd_pr__pfet_01v8_hvt ad=0.135 pd=1.27 as=0.26 ps=2.52 w=1 l=0.15
X13 Y.t2 C.t2 a_1025_297.t1 VPB.t7 sky130_fd_pr__pfet_01v8_hvt ad=0.135 pd=1.27 as=0.135 ps=1.27 w=1 l=0.15
X14 a_43_47.t0 B.t3 VPWR.t0 VPB.t0 sky130_fd_pr__pfet_01v8_hvt ad=0.135 pd=1.27 as=0.26 ps=2.52 w=1 l=0.15
X15 a_671_47.t1 C.t3 VPWR.t2 VPB.t6 sky130_fd_pr__pfet_01v8_hvt ad=0.135 pd=1.27 as=0.26 ps=2.52 w=1 l=0.15
X16 Y.t0 a_671_47.t3 a_943_47.t0 VNB.t2 sky130_fd_pr__nfet_01v8 ad=0.169 pd=1.82 as=0.08775 ps=0.92 w=0.65 l=0.15
X17 VGND.t1 A.t0 a_315_47.t2 VNB.t9 sky130_fd_pr__nfet_01v8 ad=0.08775 pd=0.92 as=0.169 ps=1.82 w=0.65 l=0.15
X18 a_481_297.t1 a_43_47.t3 a_315_47.t1 VNB.t4 sky130_fd_pr__nfet_01v8 ad=0.169 pd=1.82 as=0.08775 ps=0.92 w=0.65 l=0.15
X19 VGND.t3 a_481_297.t3 a_943_47.t1 VNB.t3 sky130_fd_pr__nfet_01v8 ad=0.08775 pd=0.92 as=0.169 ps=1.82 w=0.65 l=0.15
R0 VGND.n17 VGND.t4 282.817
R1 VGND.n5 VGND.t5 282.817
R2 VGND.n7 VGND.n6 205.2
R3 VGND.n15 VGND.n3 199.739
R4 VGND.n21 VGND.n0 34.6358
R5 VGND.n11 VGND.n2 34.6358
R6 VGND.n11 VGND.n10 34.6358
R7 VGND.n10 VGND.n9 34.6358
R8 VGND.n16 VGND.n15 25.977
R9 VGND.n3 VGND.t1 24.9236
R10 VGND.n3 VGND.t2 24.9236
R11 VGND.n6 VGND.t3 24.9236
R12 VGND.n6 VGND.t0 24.9236
R13 VGND.n17 VGND.n0 24.4711
R14 VGND.n17 VGND.n16 19.9534
R15 VGND.n15 VGND.n2 18.4476
R16 VGND.n9 VGND.n5 18.4476
R17 VGND.n16 VGND.n1 9.3005
R18 VGND.n15 VGND.n14 9.3005
R19 VGND.n13 VGND.n2 9.3005
R20 VGND.n12 VGND.n11 9.3005
R21 VGND.n10 VGND.n4 9.3005
R22 VGND.n9 VGND.n8 9.3005
R23 VGND.n18 VGND.n17 9.3005
R24 VGND.n19 VGND.n0 9.3005
R25 VGND.n21 VGND.n20 9.3005
R26 VGND.n7 VGND.n5 6.82175
R27 VGND VGND.n21 6.77697
R28 VGND.n8 VGND.n7 0.556988
R29 VGND.n20 VGND.n19 0.120292
R30 VGND.n19 VGND.n18 0.120292
R31 VGND.n18 VGND.n1 0.120292
R32 VGND.n14 VGND.n1 0.120292
R33 VGND.n14 VGND.n13 0.120292
R34 VGND.n13 VGND.n12 0.120292
R35 VGND.n12 VGND.n4 0.120292
R36 VGND.n8 VGND.n4 0.120292
R37 VGND.n20 VGND 0.0239375
R38 Y.n1 Y.n0 222.986
R39 Y.n1 Y.t0 133.469
R40 Y.n0 Y.t1 26.5955
R41 Y.n0 Y.t2 26.5955
R42 Y Y.n1 1.52823
R43 VPWR.n11 VPWR.t4 347.572
R44 VPWR.n24 VPWR.t7 347.572
R45 VPWR.n7 VPWR.t1 268.649
R46 VPWR.n6 VPWR.t3 257.474
R47 VPWR.n12 VPWR.t2 257.474
R48 VPWR.n18 VPWR.t5 257.474
R49 VPWR.n2 VPWR.t6 257.474
R50 VPWR VPWR.t0 257.096
R51 VPWR.n7 VPWR.n6 40.9353
R52 VPWR.n26 VPWR.n25 34.6358
R53 VPWR.n20 VPWR.n19 34.6358
R54 VPWR.n17 VPWR.n4 34.6358
R55 VPWR.n10 VPWR.n9 34.6358
R56 VPWR.n24 VPWR.n23 32.377
R57 VPWR.n19 VPWR.n18 32.377
R58 VPWR.n13 VPWR.n12 32.377
R59 VPWR.n13 VPWR.n11 30.8711
R60 VPWR.n20 VPWR.n2 27.8593
R61 VPWR.n26 VPWR.n0 26.3534
R62 VPWR.n29 VPWR.n28 9.3005
R63 VPWR.n27 VPWR.n26 9.3005
R64 VPWR.n25 VPWR.n1 9.3005
R65 VPWR.n23 VPWR.n22 9.3005
R66 VPWR.n21 VPWR.n20 9.3005
R67 VPWR.n19 VPWR.n3 9.3005
R68 VPWR.n17 VPWR.n16 9.3005
R69 VPWR.n15 VPWR.n4 9.3005
R70 VPWR.n14 VPWR.n13 9.3005
R71 VPWR.n10 VPWR.n5 9.3005
R72 VPWR.n9 VPWR.n8 9.3005
R73 VPWR.n29 VPWR.n0 8.28285
R74 VPWR VPWR.n29 6.77697
R75 VPWR.n23 VPWR.n2 6.77697
R76 VPWR.n11 VPWR.n10 3.76521
R77 VPWR.n25 VPWR.n24 2.25932
R78 VPWR.n18 VPWR.n17 2.25932
R79 VPWR.n12 VPWR.n4 2.25932
R80 VPWR.n9 VPWR.n6 0.753441
R81 VPWR.n8 VPWR.n7 0.697081
R82 VPWR.n0 VPWR 0.376971
R83 VPWR.n28 VPWR.n27 0.120292
R84 VPWR.n27 VPWR.n1 0.120292
R85 VPWR.n22 VPWR.n1 0.120292
R86 VPWR.n22 VPWR.n21 0.120292
R87 VPWR.n21 VPWR.n3 0.120292
R88 VPWR.n16 VPWR.n3 0.120292
R89 VPWR.n16 VPWR.n15 0.120292
R90 VPWR.n15 VPWR.n14 0.120292
R91 VPWR.n14 VPWR.n5 0.120292
R92 VPWR.n8 VPWR.n5 0.120292
R93 VPWR.n28 VPWR 0.0239375
R94 C.n1 C.t3 241.536
R95 C.n0 C.t2 241.536
R96 C.n2 C.n0 173.321
R97 C.n1 C.t1 169.237
R98 C.n0 C.t0 169.237
R99 C.n2 C.n1 152
R100 C C.n2 3.10353
R101 A.n1 A.t3 212.081
R102 A.n0 A.t2 212.081
R103 A A.n1 155.103
R104 A.n1 A.t1 139.78
R105 A.n0 A.t0 139.78
R106 A.n1 A.n0 137.298
R107 B.n1 B.t3 241.536
R108 B.n0 B.t2 241.536
R109 B.n2 B.n0 173.321
R110 B.n1 B.t1 169.237
R111 B.n0 B.t0 169.237
R112 B.n2 B.n1 152
R113 B B.n2 3.10353
R114 VPB.t8 VPB.t9 556.386
R115 VPB.t5 VPB.t6 556.386
R116 VPB.t4 VPB.t3 556.386
R117 VPB.t0 VPB.t8 248.599
R118 VPB.t9 VPB.t1 248.599
R119 VPB.t1 VPB.t5 248.599
R120 VPB.t6 VPB.t4 248.599
R121 VPB.t3 VPB.t7 248.599
R122 VPB.t7 VPB.t2 248.599
R123 VPB VPB.t0 242.679
R124 VNB.t8 VNB.t9 2677.02
R125 VNB.t4 VNB.t6 2677.02
R126 VNB.t5 VNB.t3 2677.02
R127 VNB.t0 VNB.t8 1196.12
R128 VNB.t9 VNB.t1 1196.12
R129 VNB.t1 VNB.t4 1196.12
R130 VNB.t6 VNB.t5 1196.12
R131 VNB.t3 VNB.t7 1196.12
R132 VNB.t7 VNB.t2 1196.12
R133 VNB VNB.t0 1167.64
R134 a_943_47.n0 a_943_47.t1 458.171
R135 a_943_47.t0 a_943_47.n0 24.9236
R136 a_943_47.n0 a_943_47.t2 24.9236
R137 a_753_47.t0 a_753_47.t1 49.8467
R138 a_315_47.n0 a_315_47.t2 458.171
R139 a_315_47.n0 a_315_47.t1 24.9236
R140 a_315_47.t0 a_315_47.n0 24.9236
R141 a_125_47.t0 a_125_47.t1 49.8467
R142 a_1025_297.t0 a_1025_297.t1 53.1905
R143 a_397_297.t0 a_397_297.t1 53.1905
R144 a_671_47.n1 a_671_47.t2 274.2
R145 a_671_47.n0 a_671_47.t4 241.536
R146 a_671_47.n2 a_671_47.n1 195.832
R147 a_671_47.n1 a_671_47.n0 194.357
R148 a_671_47.n0 a_671_47.t3 169.237
R149 a_671_47.t0 a_671_47.n2 26.5955
R150 a_671_47.n2 a_671_47.t1 26.5955
R151 a_481_297.n3 a_481_297.n2 212.127
R152 a_481_297.n0 a_481_297.t5 212.081
R153 a_481_297.n1 a_481_297.t6 212.081
R154 a_481_297.n2 a_481_297.n1 162.577
R155 a_481_297.n2 a_481_297.t1 144.327
R156 a_481_297.n0 a_481_297.t3 139.78
R157 a_481_297.n1 a_481_297.t4 139.78
R158 a_481_297.n1 a_481_297.n0 137.298
R159 a_481_297.t0 a_481_297.n3 26.5955
R160 a_481_297.n3 a_481_297.t2 26.5955
R161 a_43_47.n1 a_43_47.t1 274.2
R162 a_43_47.n0 a_43_47.t4 241.536
R163 a_43_47.n2 a_43_47.n1 195.832
R164 a_43_47.n1 a_43_47.n0 194.357
R165 a_43_47.n0 a_43_47.t3 169.237
R166 a_43_47.n2 a_43_47.t2 26.5955
R167 a_43_47.t0 a_43_47.n2 26.5955
C0 C VPWR 0.06217f
C1 B VPB 0.06547f
C2 VGND B 0.06289f
C3 B A 0.10725f
C4 VPB VPWR 0.24634f
C5 C VPB 0.06592f
C6 VGND VPWR 0.01075f
C7 C VGND 0.0485f
C8 A VPWR 0.04723f
C9 Y VPWR 0.08041f
C10 Y C 0.05362f
C11 VGND VPB 0.01435f
C12 VPB A 0.08835f
C13 VGND A 0.03646f
C14 Y VPB 0.00431f
C15 Y VGND 0.04829f
C16 B VPWR 0.06169f
C17 VGND VNB 0.75104f
C18 Y VNB 0.08702f
C19 VPWR VNB 0.69123f
C20 C VNB 0.13429f
C21 A VNB 0.18636f
C22 B VNB 0.18376f
C23 VPB VNB 1.36902f
C24 a_43_47.t2 VNB 0.05494f
C25 a_43_47.t1 VNB 0.16903f
C26 a_43_47.n0 VNB 0.09014f
C27 a_43_47.n1 VNB 0.52894f
C28 a_43_47.n2 VNB 0.05804f
C29 a_43_47.t0 VNB 0.06049f
C30 a_481_297.t2 VNB 0.05765f
C31 a_481_297.n0 VNB 0.09965f
C32 a_481_297.n1 VNB 0.10911f
C33 a_481_297.t1 VNB 0.07975f
C34 a_481_297.n2 VNB 0.41997f
C35 a_481_297.n3 VNB 0.06034f
C36 a_481_297.t0 VNB 0.0579f
C37 a_671_47.t2 VNB 0.17268f
C38 a_671_47.n0 VNB 0.09086f
C39 a_671_47.n1 VNB 0.53317f
C40 a_671_47.t1 VNB 0.06415f
C41 a_671_47.n2 VNB 0.05851f
C42 a_671_47.t0 VNB 0.05587f
C43 a_397_297.t1 VNB 0.0442f
C44 a_397_297.t0 VNB 0.04975f
C45 a_1025_297.t1 VNB 0.05332f
C46 a_1025_297.t0 VNB 0.04504f
C47 a_125_47.t1 VNB 0.02787f
C48 a_125_47.t0 VNB 0.03248f
C49 a_315_47.t1 VNB 0.03619f
C50 a_315_47.t2 VNB 0.09887f
C51 a_315_47.n0 VNB 0.06369f
C52 a_315_47.t0 VNB 0.03637f
C53 a_753_47.t1 VNB 0.03563f
C54 a_753_47.t0 VNB 0.02903f
C55 a_943_47.t2 VNB 0.03913f
C56 a_943_47.t1 VNB 0.101f
C57 a_943_47.n0 VNB 0.06499f
C58 a_943_47.t0 VNB 0.03664f
C59 VPB.t2 VNB 0.09853f
C60 VPB.t7 VNB 0.04356f
C61 VPB.t3 VNB 0.07053f
C62 VPB.t4 VNB 0.07053f
C63 VPB.t6 VNB 0.07053f
C64 VPB.t5 VNB 0.07053f
C65 VPB.t1 VNB 0.04356f
C66 VPB.t9 VNB 0.07053f
C67 VPB.t8 VNB 0.07053f
C68 VPB.t0 VNB 0.04304f
C69 B.n0 VNB 0.07927f
C70 B.n1 VNB 0.06452f
C71 B.n2 VNB 0.22422f
C72 A.n0 VNB 0.09708f
C73 A.n1 VNB 0.10472f
C74 C.n0 VNB 0.08773f
C75 C.n1 VNB 0.07141f
C76 C.n2 VNB 0.24814f
C77 VPWR.t0 VNB 0.07559f
C78 VPWR.n0 VNB 0.0065f
C79 VPWR.n1 VNB 0.03634f
C80 VPWR.t7 VNB 0.06855f
C81 VPWR.t6 VNB 0.07009f
C82 VPWR.n2 VNB 0.0377f
C83 VPWR.n3 VNB 0.03634f
C84 VPWR.t5 VNB 0.07539f
C85 VPWR.n4 VNB 0.00685f
C86 VPWR.n5 VNB 0.03634f
C87 VPWR.t4 VNB 0.06925f
C88 VPWR.t3 VNB 0.0708f
C89 VPWR.n6 VNB 0.04012f
C90 VPWR.t1 VNB 0.07751f
C91 VPWR.n7 VNB 0.08366f
C92 VPWR.n8 VNB 0.12712f
C93 VPWR.n9 VNB 0.00657f
C94 VPWR.n10 VNB 0.00713f
C95 VPWR.n11 VNB 0.02973f
C96 VPWR.t2 VNB 0.07908f
C97 VPWR.n12 VNB 0.0377f
C98 VPWR.n13 VNB 0.01175f
C99 VPWR.n14 VNB 0.03634f
C100 VPWR.n15 VNB 0.03634f
C101 VPWR.n16 VNB 0.03634f
C102 VPWR.n17 VNB 0.00685f
C103 VPWR.n18 VNB 0.0377f
C104 VPWR.n19 VNB 0.01245f
C105 VPWR.n20 VNB 0.01161f
C106 VPWR.n21 VNB 0.03634f
C107 VPWR.n22 VNB 0.03634f
C108 VPWR.n23 VNB 0.00727f
C109 VPWR.n24 VNB 0.02973f
C110 VPWR.n25 VNB 0.00685f
C111 VPWR.n26 VNB 0.01133f
C112 VPWR.n27 VNB 0.03634f
C113 VPWR.n28 VNB 0.02172f
C114 VPWR.n29 VNB 0.0028f
C115 Y.t1 VNB 0.05435f
C116 Y.t2 VNB 0.05778f
C117 Y.n0 VNB 0.06158f
C118 Y.t0 VNB 0.06739f
C119 Y.n1 VNB 0.2119f
C120 VGND.n0 VNB 0.00797f
C121 VGND.n1 VNB 0.02637f
C122 VGND.n2 VNB 0.00716f
C123 VGND.t2 VNB 0.02854f
C124 VGND.t1 VNB 0.02393f
C125 VGND.n3 VNB 0.01128f
C126 VGND.n4 VNB 0.02637f
C127 VGND.t5 VNB 0.03779f
C128 VGND.n5 VNB 0.03025f
C129 VGND.t0 VNB 0.03102f
C130 VGND.t3 VNB 0.02442f
C131 VGND.n6 VNB 0.01219f
C132 VGND.n7 VNB 0.07213f
C133 VGND.n8 VNB 0.13452f
C134 VGND.n9 VNB 0.00716f
C135 VGND.n10 VNB 0.00934f
C136 VGND.n11 VNB 0.00934f
C137 VGND.n12 VNB 0.02637f
C138 VGND.n13 VNB 0.02637f
C139 VGND.n14 VNB 0.02637f
C140 VGND.n15 VNB 0.02686f
C141 VGND.n16 VNB 0.00619f
C142 VGND.t4 VNB 0.03729f
C143 VGND.n17 VNB 0.02924f
C144 VGND.n18 VNB 0.02637f
C145 VGND.n19 VNB 0.02637f
C146 VGND.n20 VNB 0.01576f
C147 VGND.n21 VNB 0.00558f
.ends
