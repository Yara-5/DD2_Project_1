.subckt dd2_g5__xor3_1 A B C VGND VNB VPB VPWR Y
X0 VGND A a_591_47.t0 VNB sky130_fd_pr__nfet_01v8 ad=0.17225 pd=1.18 as=0.10075 ps=0.96 w=0.65 l=0.15
X1 Y a_819_297.t0 a_1061_47.t0 VNB sky130_fd_pr__nfet_01v8 ad=0.169 pd=1.82 as=0.17225 ps=1.18 w=0.65 l=0.15
X2 a_819_47.t0 a_267_297.t1 VGND VNB sky130_fd_pr__nfet_01v8 ad=0.17225 pd=1.18 as=0.17225 ps=1.18 w=0.65 l=0.15
X3 VPWR a_819_297.t0 Y VPB sky130_fd_pr__pfet_01v8_hvt ad=0.26 pd=2.52 as=0.265 ps=1.53 w=1 l=0.15
X4 Y C a_1143_297.t0 VPB sky130_fd_pr__pfet_01v8_hvt ad=0.265 pd=1.53 as=0.155 ps=1.31 w=1 l=0.15
X5 a_267_297.t1 a_363_199.t0 a_49_47.t0 VNB sky130_fd_pr__nfet_01v8 ad=0.169 pd=1.82 as=0.17225 ps=1.18 w=0.65 l=0.15
X6 VPWR A a_363_199.t0 VPB sky130_fd_pr__pfet_01v8_hvt ad=0.265 pd=1.53 as=0.155 ps=1.31 w=1 l=0.15
X7 a_819_297.t0 a_267_297.t1 VPWR VPB sky130_fd_pr__pfet_01v8_hvt ad=0.265 pd=1.53 as=0.265 ps=1.53 w=1 l=0.15
X8 a_1061_47.t0 C VGND VNB sky130_fd_pr__nfet_01v8 ad=0.17225 pd=1.18 as=0.10075 ps=0.96 w=0.65 l=0.15
X9 VPWR C a_819_297.t0 VPB sky130_fd_pr__pfet_01v8_hvt ad=0.26 pd=2.52 as=0.265 ps=1.53 w=1 l=0.15
X10 VGND A a_49_47.t0 VNB sky130_fd_pr__nfet_01v8 ad=0.17225 pd=1.18 as=0.169 ps=1.82 w=0.65 l=0.15
X11 a_591_47.t0 B a_363_199.t0 VNB sky130_fd_pr__nfet_01v8 ad=0.10075 pd=0.96 as=0.169 ps=1.82 w=0.65 l=0.15
X12 a_49_47.t0 B VGND VNB sky130_fd_pr__nfet_01v8 ad=0.17225 pd=1.18 as=0.17225 ps=1.18 w=0.65 l=0.15
X13 VPWR a_363_199.t0 a_267_297.t1 VPB sky130_fd_pr__pfet_01v8_hvt ad=0.26 pd=2.52 as=0.265 ps=1.53 w=1 l=0.15
X14 a_131_297.t0 A VPWR VPB sky130_fd_pr__pfet_01v8_hvt ad=0.265 pd=1.53 as=0.26 ps=2.52 w=1 l=0.15
X15 a_267_297.t1 B a_131_297.t0 VPB sky130_fd_pr__pfet_01v8_hvt ad=0.265 pd=1.53 as=0.265 ps=1.53 w=1 l=0.15
X16 a_819_297.t0 C a_819_47.t0 VNB sky130_fd_pr__nfet_01v8 ad=0.169 pd=1.82 as=0.17225 ps=1.18 w=0.65 l=0.15
X17 a_1143_297.t0 a_267_297.t1 VPWR VPB sky130_fd_pr__pfet_01v8_hvt ad=0.155 pd=1.31 as=0.26 ps=2.52 w=1 l=0.15
X18 a_363_199.t0 B VPWR VPB sky130_fd_pr__pfet_01v8_hvt ad=0.155 pd=1.31 as=0.26 ps=2.52 w=1 l=0.15
X19 VGND a_267_297.t1 a_1061_47.t0 VNB sky130_fd_pr__nfet_01v8 ad=0.10075 pd=0.96 as=0.169 ps=1.82 w=0.65 l=0.15
.ends dd2_g5__xor3_1
