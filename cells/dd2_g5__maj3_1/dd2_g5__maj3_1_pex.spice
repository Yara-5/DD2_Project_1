* NGSPICE file created from dd2_g5__maj3_1.ext - technology: sky130A

.subckt dd2_g5__maj3_1 A B C VGND VNB VPB VPWR Y
X0 a_223_47.t0 A.t1 a_141_47.t1 VNB.t0 sky130_fd_pr__nfet_01v8 ad=0.17225 pd=1.18 as=0.169 ps=1.82 w=0.65 l=0.15
X1 a_359_47.t3 B.t1 a_223_47.t1 VNB.t4 sky130_fd_pr__nfet_01v8 ad=0.17875 pd=1.2 as=0.17225 ps=1.18 w=0.65 l=0.15
X2 VGND.t2 A.t0 a_141_47.t0 VNB.t1 sky130_fd_pr__nfet_01v8 ad=0.09425 pd=0.94 as=0.17225 ps=1.18 w=0.65 l=0.15
X3 Y.t0 a_359_47.t4 VGND.t0 VNB.t2 sky130_fd_pr__nfet_01v8 ad=0.169 pd=1.82 as=0.169 ps=1.82 w=0.65 l=0.15
X4 VPWR.t0 B.t2 a_635_297.t1 VPB.t5 sky130_fd_pr__pfet_01v8_hvt ad=0.26 pd=2.52 as=0.145 ps=1.29 w=1 l=0.15
X5 a_141_47.t2 C.t0 a_359_47.t1 VNB.t3 sky130_fd_pr__nfet_01v8 ad=0.17225 pd=1.18 as=0.17875 ps=1.2 w=0.65 l=0.15
X6 Y.t1 a_359_47.t5 VPWR.t2 VPB.t2 sky130_fd_pr__pfet_01v8_hvt ad=0.26 pd=2.52 as=0.26 ps=2.52 w=1 l=0.15
X7 a_359_47.t2 C.t1 a_141_297.t1 VPB.t3 sky130_fd_pr__pfet_01v8_hvt ad=0.265 pd=1.53 as=0.275 ps=1.55 w=1 l=0.15
X8 VPWR.t3 A.t3 a_141_297.t0 VPB.t0 sky130_fd_pr__pfet_01v8_hvt ad=0.265 pd=1.53 as=0.26 ps=2.52 w=1 l=0.15
X9 a_141_47.t3 B.t0 VGND.t1 VNB.t5 sky130_fd_pr__nfet_01v8 ad=0.169 pd=1.82 as=0.09425 ps=0.94 w=0.65 l=0.15
X10 a_635_297.t0 A.t2 a_359_47.t0 VPB.t1 sky130_fd_pr__pfet_01v8_hvt ad=0.145 pd=1.29 as=0.265 ps=1.53 w=1 l=0.15
X11 a_141_297.t2 B.t3 VPWR.t1 VPB.t4 sky130_fd_pr__pfet_01v8_hvt ad=0.275 pd=1.55 as=0.265 ps=1.53 w=1 l=0.15
R0 VGND.n3 VGND.t0 288.123
R1 VGND.n5 VGND.n4 199.739
R2 VGND.n16 VGND.n0 34.6358
R3 VGND.n12 VGND.n0 34.6358
R4 VGND.n12 VGND.n11 34.6358
R5 VGND.n11 VGND.n10 34.6358
R6 VGND.n10 VGND.n2 34.6358
R7 VGND.n6 VGND.n2 34.6358
R8 VGND.n4 VGND.t2 26.7697
R9 VGND.n4 VGND.t1 26.7697
R10 VGND.n6 VGND.n5 12.424
R11 VGND.n7 VGND.n6 9.3005
R12 VGND.n8 VGND.n2 9.3005
R13 VGND.n10 VGND.n9 9.3005
R14 VGND.n11 VGND.n1 9.3005
R15 VGND.n13 VGND.n12 9.3005
R16 VGND.n14 VGND.n0 9.3005
R17 VGND.n16 VGND.n15 9.3005
R18 VGND.n5 VGND.n3 7.04243
R19 VGND VGND.n16 6.77697
R20 VGND.n7 VGND.n3 0.576735
R21 VGND.n15 VGND.n14 0.120292
R22 VGND.n14 VGND.n13 0.120292
R23 VGND.n13 VGND.n1 0.120292
R24 VGND.n9 VGND.n1 0.120292
R25 VGND.n9 VGND.n8 0.120292
R26 VGND.n8 VGND.n7 0.120292
R27 VGND.n15 VGND 0.0239375
R28 Y.n0 Y.t1 389.846
R29 Y.n0 Y.t0 209.923
R30 Y.n1 Y 6.4005
R31 Y Y.n1 3.2005
R32 Y.n1 Y.n0 0.213833
R33 VPWR.n5 VPWR.t2 349.478
R34 VPWR.n6 VPWR.t0 341.466
R35 VPWR.n14 VPWR.n2 314.87
R36 VPWR.n2 VPWR.t3 52.2055
R37 VPWR.n2 VPWR.t1 52.2055
R38 VPWR.n19 VPWR.n0 34.6358
R39 VPWR.n15 VPWR.n0 34.6358
R40 VPWR.n13 VPWR.n12 34.6358
R41 VPWR.n12 VPWR.n3 34.6358
R42 VPWR.n8 VPWR.n3 34.6358
R43 VPWR.n8 VPWR.n7 34.6358
R44 VPWR.n7 VPWR.n6 22.5887
R45 VPWR.n15 VPWR.n14 17.3181
R46 VPWR.n14 VPWR.n13 17.3181
R47 VPWR.n6 VPWR.n5 16.9256
R48 VPWR.n19 VPWR.n18 9.3005
R49 VPWR.n17 VPWR.n0 9.3005
R50 VPWR.n16 VPWR.n15 9.3005
R51 VPWR.n13 VPWR.n1 9.3005
R52 VPWR.n12 VPWR.n11 9.3005
R53 VPWR.n10 VPWR.n3 9.3005
R54 VPWR.n9 VPWR.n8 9.3005
R55 VPWR.n7 VPWR.n4 9.3005
R56 VPWR VPWR.n19 6.77697
R57 VPWR.n5 VPWR.n4 2.86984
R58 VPWR.n18 VPWR.n17 0.120292
R59 VPWR.n17 VPWR.n16 0.120292
R60 VPWR.n16 VPWR.n1 0.120292
R61 VPWR.n11 VPWR.n1 0.120292
R62 VPWR.n11 VPWR.n10 0.120292
R63 VPWR.n10 VPWR.n9 0.120292
R64 VPWR.n9 VPWR.n4 0.120292
R65 VPWR.n18 VPWR 0.0239375
R66 C.n0 C.t1 241.536
R67 C.n0 C.t0 169.237
R68 C C.n0 155.103
R69 B.n1 B.t3 241.536
R70 B.n0 B.t2 229.369
R71 B.n2 B.n0 172.512
R72 B.n1 B.t1 169.237
R73 B.n0 B.t0 157.07
R74 B.n2 B.n1 152
R75 B B.n2 3.10353
R76 A.n1 A.t3 241.536
R77 A.n0 A.t2 241.536
R78 A.n2 A.n0 172.512
R79 A.n1 A.t1 169.237
R80 A.n0 A.t0 169.237
R81 A.n2 A.n1 152
R82 A A.n2 3.10353
R83 VPB.t5 VPB.t2 556.386
R84 VPB VPB.t0 532.711
R85 VPB.t4 VPB.t3 414.33
R86 VPB.t3 VPB.t1 402.493
R87 VPB.t0 VPB.t4 402.493
R88 VPB.t1 VPB.t5 260.437
R89 VNB.t5 VNB.t2 2677.02
R90 VNB VNB.t0 2563.11
R91 VNB.t4 VNB.t3 1993.53
R92 VNB.t3 VNB.t1 1936.57
R93 VNB.t0 VNB.t4 1936.57
R94 VNB.t1 VNB.t5 1253.07
R95 a_223_47.t0 a_223_47.t1 97.8467
R96 a_141_47.n0 a_141_47.t1 215.839
R97 a_141_47.n0 a_141_47.t3 209.923
R98 a_141_47.n1 a_141_47.n0 157.827
R99 a_141_47.t0 a_141_47.n1 48.9236
R100 a_141_47.n1 a_141_47.t2 48.9236
R101 a_635_297.t0 a_635_297.t1 57.1305
R102 a_141_297.t0 a_141_297.n0 498.745
R103 a_141_297.n0 a_141_297.t1 54.1755
R104 a_141_297.n0 a_141_297.t2 54.1755
R105 a_359_47.n2 a_359_47.n0 290.753
R106 a_359_47.n0 a_359_47.t5 241.536
R107 a_359_47.n3 a_359_47.n2 196.221
R108 a_359_47.n0 a_359_47.t4 169.237
R109 a_359_47.n2 a_359_47.n1 136.685
R110 a_359_47.t0 a_359_47.n3 52.2055
R111 a_359_47.n3 a_359_47.t2 52.2055
R112 a_359_47.n1 a_359_47.t1 50.7697
R113 a_359_47.n1 a_359_47.t3 50.7697
C0 B A 0.16887f
C1 VPB A 0.07609f
C2 VGND A 0.02498f
C3 B C 0.0378f
C4 B Y 0.00119f
C5 C VPB 0.03242f
C6 VPB Y 0.01962f
C7 C VGND 0.01372f
C8 VGND Y 0.02363f
C9 B VPWR 0.03601f
C10 VPWR VPB 0.18117f
C11 VPWR VGND 0.01925f
C12 C A 0.03361f
C13 Y A 0
C14 C Y 0
C15 VPWR A 0.02858f
C16 VPWR C 0.0124f
C17 VPWR Y 0.03262f
C18 B VPB 0.07551f
C19 B VGND 0.08976f
C20 VPB VGND 0.01857f
C21 VGND VNB 0.66798f
C22 Y VNB 0.06819f
C23 VPWR VNB 0.5281f
C24 C VNB 0.08912f
C25 B VNB 0.17603f
C26 A VNB 0.17957f
C27 VPB VNB 1.20647f
C28 a_359_47.n0 VNB 0.11028f
C29 a_359_47.t1 VNB 0.05642f
C30 a_359_47.t3 VNB 0.06224f
C31 a_359_47.n1 VNB 0.13385f
C32 a_359_47.n2 VNB 0.56256f
C33 a_359_47.t2 VNB 0.08176f
C34 a_359_47.n3 VNB 0.11222f
C35 a_359_47.t0 VNB 0.09055f
C36 a_141_297.t1 VNB 0.06414f
C37 a_141_297.t2 VNB 0.07218f
C38 a_141_297.n0 VNB 0.18411f
C39 a_141_297.t0 VNB 0.19886f
C40 a_635_297.t1 VNB 0.05244f
C41 a_635_297.t0 VNB 0.05368f
C42 a_141_47.t2 VNB 0.05842f
C43 a_141_47.t1 VNB 0.23223f
C44 a_141_47.t3 VNB 0.09488f
C45 a_141_47.n0 VNB 0.63201f
C46 a_141_47.n1 VNB 0.12293f
C47 a_141_47.t0 VNB 0.06478f
C48 a_223_47.t1 VNB 0.04619f
C49 a_223_47.t0 VNB 0.04674f
C50 VPB.t2 VNB 0.15285f
C51 VPB.t5 VNB 0.06204f
C52 VPB.t1 VNB 0.05035f
C53 VPB.t3 VNB 0.06204f
C54 VPB.t4 VNB 0.06204f
C55 VPB.t0 VNB 0.07103f
C56 A.n0 VNB 0.08831f
C57 A.n1 VNB 0.0705f
C58 A.n2 VNB 0.27498f
C59 B.n0 VNB 0.11649f
C60 B.n1 VNB 0.06899f
C61 B.n2 VNB 0.26909f
C62 C.n0 VNB 0.05318f
C63 VPWR.n0 VNB 0.01134f
C64 VPWR.n1 VNB 0.03203f
C65 VPWR.t1 VNB 0.05368f
C66 VPWR.t3 VNB 0.05444f
C67 VPWR.n2 VNB 0.04029f
C68 VPWR.n3 VNB 0.01134f
C69 VPWR.n4 VNB 0.1776f
C70 VPWR.t0 VNB 0.07122f
C71 VPWR.t2 VNB 0.07009f
C72 VPWR.n5 VNB 0.0515f
C73 VPWR.n6 VNB 0.03759f
C74 VPWR.n7 VNB 0.00937f
C75 VPWR.n8 VNB 0.01134f
C76 VPWR.n9 VNB 0.03203f
C77 VPWR.n10 VNB 0.03203f
C78 VPWR.n11 VNB 0.03203f
C79 VPWR.n12 VNB 0.01134f
C80 VPWR.n13 VNB 0.00851f
C81 VPWR.n14 VNB 0.03342f
C82 VPWR.n15 VNB 0.00851f
C83 VPWR.n16 VNB 0.03203f
C84 VPWR.n17 VNB 0.03203f
C85 VPWR.n18 VNB 0.01915f
C86 VPWR.n19 VNB 0.00678f
C87 Y.t1 VNB 0.08464f
C88 Y.t0 VNB 0.05203f
C89 Y.n0 VNB 0.05533f
C90 Y.n1 VNB 0.00601f
C91 VGND.n0 VNB 0.00894f
C92 VGND.n1 VNB 0.02524f
C93 VGND.n2 VNB 0.00894f
C94 VGND.t0 VNB 0.04152f
C95 VGND.n3 VNB 0.07005f
C96 VGND.t1 VNB 0.0299f
C97 VGND.t2 VNB 0.03084f
C98 VGND.n4 VNB 0.01154f
C99 VGND.n5 VNB 0.02643f
C100 VGND.n6 VNB 0.00607f
C101 VGND.n7 VNB 0.13126f
C102 VGND.n8 VNB 0.02524f
C103 VGND.n9 VNB 0.02524f
C104 VGND.n10 VNB 0.00894f
C105 VGND.n11 VNB 0.00894f
C106 VGND.n12 VNB 0.00894f
C107 VGND.n13 VNB 0.02524f
C108 VGND.n14 VNB 0.02524f
C109 VGND.n15 VNB 0.01509f
C110 VGND.n16 VNB 0.00534f
.ends
