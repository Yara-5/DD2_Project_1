* NGSPICE file created from dd2_g5__maj3_1.ext - technology: sky130A

.subckt dd2_g5__maj3_1 A B C VGND VNB VPB VPWR Y
X0 Y.t1 a_267_47.t4 VGND.t1 VNB.t2 sky130_fd_pr__nfet_01v8 ad=0.169 pd=1.82 as=0.169 ps=1.82 w=0.65 l=0.15
X1 VPWR.t2 B.t2 a_543_297.t1 VPB.t5 sky130_fd_pr__pfet_01v8_hvt ad=0.26 pd=2.52 as=0.145 ps=1.29 w=1 l=0.15
X2 a_49_47.t3 B.t0 VGND.t2 VNB.t5 sky130_fd_pr__nfet_01v8 ad=0.169 pd=1.82 as=0.09425 ps=0.94 w=0.65 l=0.15
X3 Y.t0 a_267_47.t5 VPWR.t0 VPB.t2 sky130_fd_pr__pfet_01v8_hvt ad=0.26 pd=2.52 as=0.26 ps=2.52 w=1 l=0.15
X4 a_267_47.t2 C.t1 a_49_297.t1 VPB.t3 sky130_fd_pr__pfet_01v8_hvt ad=0.265 pd=1.53 as=0.275 ps=1.55 w=1 l=0.15
X5 a_131_47.t0 A.t1 a_49_47.t1 VNB.t0 sky130_fd_pr__nfet_01v8 ad=0.17225 pd=1.18 as=0.169 ps=1.82 w=0.65 l=0.15
X6 a_543_297.t0 A.t2 a_267_47.t0 VPB.t1 sky130_fd_pr__pfet_01v8_hvt ad=0.145 pd=1.29 as=0.265 ps=1.53 w=1 l=0.15
X7 a_267_47.t3 B.t1 a_131_47.t1 VNB.t4 sky130_fd_pr__nfet_01v8 ad=0.17875 pd=1.2 as=0.17225 ps=1.18 w=0.65 l=0.15
X8 VGND.t0 A.t0 a_49_47.t0 VNB.t1 sky130_fd_pr__nfet_01v8 ad=0.09425 pd=0.94 as=0.17225 ps=1.18 w=0.65 l=0.15
X9 VPWR.t1 A.t3 a_49_297.t0 VPB.t0 sky130_fd_pr__pfet_01v8_hvt ad=0.265 pd=1.53 as=0.26 ps=2.52 w=1 l=0.15
X10 a_49_297.t2 B.t3 VPWR.t3 VPB.t4 sky130_fd_pr__pfet_01v8_hvt ad=0.275 pd=1.55 as=0.265 ps=1.53 w=1 l=0.15
X11 a_49_47.t2 C.t0 a_267_47.t1 VNB.t3 sky130_fd_pr__nfet_01v8 ad=0.17225 pd=1.18 as=0.17875 ps=1.2 w=0.65 l=0.15
R0 VGND.n5 VGND.t1 288.154
R1 VGND.n4 VGND.n3 199.739
R2 VGND.n14 VGND.n0 34.6358
R3 VGND.n10 VGND.n0 34.6358
R4 VGND.n10 VGND.n9 34.6358
R5 VGND.n9 VGND.n8 34.6358
R6 VGND.n8 VGND.n2 34.6358
R7 VGND.n3 VGND.t0 26.7697
R8 VGND.n3 VGND.t2 26.7697
R9 VGND.n4 VGND.n2 12.424
R10 VGND.n6 VGND.n2 9.3005
R11 VGND.n8 VGND.n7 9.3005
R12 VGND.n9 VGND.n1 9.3005
R13 VGND.n11 VGND.n10 9.3005
R14 VGND.n12 VGND.n0 9.3005
R15 VGND.n14 VGND.n13 9.3005
R16 VGND.n5 VGND.n4 7.04
R17 VGND VGND.n14 6.77697
R18 VGND.n6 VGND.n5 0.57936
R19 VGND.n13 VGND.n12 0.120292
R20 VGND.n12 VGND.n11 0.120292
R21 VGND.n11 VGND.n1 0.120292
R22 VGND.n7 VGND.n1 0.120292
R23 VGND.n7 VGND.n6 0.120292
R24 VGND.n13 VGND 0.0239375
R25 Y.n0 Y.t0 895.778
R26 Y.n0 Y.t1 209.923
R27 Y.n1 Y 6.4005
R28 Y Y.n1 3.2005
R29 Y.n1 Y.n0 0.213833
R30 VPWR.n3 VPWR.t0 884.225
R31 VPWR.n4 VPWR.t2 876.193
R32 VPWR.n12 VPWR.n11 607.212
R33 VPWR.n11 VPWR.t1 52.2055
R34 VPWR.n11 VPWR.t3 52.2055
R35 VPWR.n17 VPWR.n0 34.6358
R36 VPWR.n13 VPWR.n10 34.6358
R37 VPWR.n10 VPWR.n9 34.6358
R38 VPWR.n9 VPWR.n2 34.6358
R39 VPWR.n5 VPWR.n2 34.6358
R40 VPWR.n5 VPWR.n4 22.5887
R41 VPWR.n12 VPWR.n0 17.3181
R42 VPWR.n13 VPWR.n12 17.3181
R43 VPWR.n4 VPWR.n3 16.9208
R44 VPWR.n17 VPWR.n16 9.3005
R45 VPWR.n15 VPWR.n0 9.3005
R46 VPWR.n14 VPWR.n13 9.3005
R47 VPWR.n10 VPWR.n1 9.3005
R48 VPWR.n9 VPWR.n8 9.3005
R49 VPWR.n7 VPWR.n2 9.3005
R50 VPWR.n6 VPWR.n5 9.3005
R51 VPWR VPWR.n17 6.77697
R52 VPWR.n6 VPWR.n3 2.87627
R53 VPWR.n16 VPWR.n15 0.120292
R54 VPWR.n15 VPWR.n14 0.120292
R55 VPWR.n14 VPWR.n1 0.120292
R56 VPWR.n8 VPWR.n1 0.120292
R57 VPWR.n8 VPWR.n7 0.120292
R58 VPWR.n7 VPWR.n6 0.120292
R59 VPWR.n16 VPWR 0.0239375
R60 C.n0 C.t1 241.536
R61 C.n0 C.t0 169.237
R62 C C.n0 155.103
R63 B.n0 B.t3 241.536
R64 B.n1 B.t2 229.369
R65 B B.n1 224.463
R66 B.n0 B.t1 169.237
R67 B B.n0 157.69
R68 B.n1 B.t0 157.07
R69 A.n1 A.t3 241.536
R70 A.n0 A.t2 241.536
R71 A.n2 A.n0 224.395
R72 A.n1 A.t1 169.237
R73 A.n0 A.t0 169.237
R74 A.n2 A.n1 152
R75 A A.n2 6.02403
R76 VPB.t5 VPB.t2 556.386
R77 VPB.t4 VPB.t3 414.33
R78 VPB.t3 VPB.t1 402.493
R79 VPB.t0 VPB.t4 402.493
R80 VPB.t1 VPB.t5 260.437
R81 VPB VPB.t0 260.437
R82 VNB.t5 VNB.t2 2677.02
R83 VNB.t4 VNB.t3 1993.53
R84 VNB.t3 VNB.t1 1936.57
R85 VNB.t0 VNB.t4 1936.57
R86 VNB.t1 VNB.t5 1253.07
R87 VNB VNB.t0 1253.07
R88 a_131_47.t0 a_131_47.t1 97.8467
R89 a_49_47.n0 a_49_47.t1 417.207
R90 a_49_47.n1 a_49_47.n0 259.541
R91 a_49_47.n0 a_49_47.t3 209.923
R92 a_49_47.t0 a_49_47.n1 48.9236
R93 a_49_47.n1 a_49_47.t2 48.9236
R94 a_543_297.t0 a_543_297.t1 57.1305
R95 a_49_297.t0 a_49_297.n0 1509.61
R96 a_49_297.n0 a_49_297.t1 54.1755
R97 a_49_297.n0 a_49_297.t2 54.1755
R98 a_267_47.n3 a_267_47.n2 585
R99 a_267_47.n2 a_267_47.n1 326.264
R100 a_267_47.n2 a_267_47.n0 292.312
R101 a_267_47.n0 a_267_47.t5 241.536
R102 a_267_47.n0 a_267_47.t4 169.237
R103 a_267_47.t0 a_267_47.n3 52.2055
R104 a_267_47.n3 a_267_47.t2 52.2055
R105 a_267_47.n1 a_267_47.t1 50.7697
R106 a_267_47.n1 a_267_47.t3 50.7697
C0 VPB VPWR 0.14268f
C1 VGND A 0.03097f
C2 VPB A 0.06784f
C3 VPWR C 0.01037f
C4 VGND Y 0.02418f
C5 B VGND 0.09581f
C6 C A 0.04357f
C7 VPB Y 0.01106f
C8 B VPB 0.07428f
C9 VPWR A 0.0295f
C10 Y C 0
C11 B C 0.02891f
C12 VPWR Y 0.01976f
C13 B VPWR 0.03187f
C14 Y A 0
C15 B A 0.16397f
C16 VPB VGND 0.00815f
C17 B Y 0.0015f
C18 VGND C 0.01396f
C19 VPB C 0.03236f
C20 VPWR VGND 0.01394f
C21 VGND VNB 0.56144f
C22 Y VNB 0.06266f
C23 VPWR VNB 0.4548f
C24 C VNB 0.08886f
C25 B VNB 0.41664f
C26 A VNB 0.16942f
C27 VPB VNB 1.00988f
C28 a_267_47.t2 VNB 0.07747f
C29 a_267_47.n0 VNB 0.09955f
C30 a_267_47.t1 VNB 0.05359f
C31 a_267_47.t3 VNB 0.05901f
C32 a_267_47.n1 VNB 0.12033f
C33 a_267_47.n2 VNB 0.37104f
C34 a_267_47.n3 VNB 0.09979f
C35 a_267_47.t0 VNB 0.08405f
C36 a_49_297.t1 VNB 0.06156f
C37 a_49_297.t2 VNB 0.06905f
C38 a_49_297.n0 VNB 0.11379f
C39 a_49_297.t0 VNB 0.1253f
C40 a_543_297.t1 VNB 0.04944f
C41 a_543_297.t0 VNB 0.04903f
C42 a_49_47.t2 VNB 0.05368f
C43 a_49_47.t1 VNB 0.24346f
C44 a_49_47.t3 VNB 0.08534f
C45 a_49_47.n0 VNB 0.51838f
C46 a_49_47.n1 VNB 0.08164f
C47 a_49_47.t0 VNB 0.05844f
C48 a_131_47.t1 VNB 0.04308f
C49 a_131_47.t0 VNB 0.04242f
C50 VPB.t2 VNB 0.11438f
C51 VPB.t5 VNB 0.06365f
C52 VPB.t1 VNB 0.05166f
C53 VPB.t3 VNB 0.06365f
C54 VPB.t4 VNB 0.06365f
C55 VPB.t0 VNB 0.05166f
C56 A.n0 VNB 0.10811f
C57 A.n1 VNB 0.06839f
C58 A.n2 VNB 0.2031f
C59 B.n0 VNB 0.07081f
C60 B.n1 VNB 0.14938f
C61 C.n0 VNB 0.05551f
C62 VPWR.n0 VNB 0.00795f
C63 VPWR.n1 VNB 0.02993f
C64 VPWR.n2 VNB 0.0106f
C65 VPWR.t0 VNB 0.06092f
C66 VPWR.n3 VNB 0.0325f
C67 VPWR.t2 VNB 0.06651f
C68 VPWR.n4 VNB 0.02093f
C69 VPWR.n5 VNB 0.00876f
C70 VPWR.n6 VNB 0.12752f
C71 VPWR.n7 VNB 0.02993f
C72 VPWR.n8 VNB 0.02993f
C73 VPWR.n9 VNB 0.0106f
C74 VPWR.n10 VNB 0.0106f
C75 VPWR.t3 VNB 0.05303f
C76 VPWR.t1 VNB 0.05212f
C77 VPWR.n11 VNB 0.03618f
C78 VPWR.n12 VNB 0.01564f
C79 VPWR.n13 VNB 0.00795f
C80 VPWR.n14 VNB 0.02993f
C81 VPWR.n15 VNB 0.02993f
C82 VPWR.n16 VNB 0.01789f
C83 VPWR.n17 VNB 0.00634f
C84 Y.t0 VNB 0.06746f
C85 Y.t1 VNB 0.04508f
C86 Y.n0 VNB 0.04279f
C87 Y.n1 VNB 0.00504f
C88 VGND.n0 VNB 0.00905f
C89 VGND.n1 VNB 0.02555f
C90 VGND.n2 VNB 0.00615f
C91 VGND.t1 VNB 0.03946f
C92 VGND.t2 VNB 0.03039f
C93 VGND.t0 VNB 0.03015f
C94 VGND.n3 VNB 0.01168f
C95 VGND.n4 VNB 0.02676f
C96 VGND.n5 VNB 0.06164f
C97 VGND.n6 VNB 0.1076f
C98 VGND.n7 VNB 0.02555f
C99 VGND.n8 VNB 0.00905f
C100 VGND.n9 VNB 0.00905f
C101 VGND.n10 VNB 0.00905f
C102 VGND.n11 VNB 0.02555f
C103 VGND.n12 VNB 0.02555f
C104 VGND.n13 VNB 0.01528f
C105 VGND.n14 VNB 0.00541f
.ends
