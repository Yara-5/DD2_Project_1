* NGSPICE file created from dd2_g5__maj3_1.ext - technology: sky130A

.subckt dd2_g5__maj3_1 A B C VGND VNB VPB VPWR Y
X0 Y a_267_47# VGND VNB sky130_fd_pr__nfet_01v8 ad=0.169 pd=1.82 as=0.169 ps=1.82 w=0.65 l=0.15
X1 VPWR B a_543_297# VPB sky130_fd_pr__pfet_01v8_hvt ad=0.26 pd=2.52 as=0.145 ps=1.29 w=1 l=0.15
X2 a_49_47# B VGND VNB sky130_fd_pr__nfet_01v8 ad=0.169 pd=1.82 as=0.09425 ps=0.94 w=0.65 l=0.15
X3 Y a_267_47# VPWR VPB sky130_fd_pr__pfet_01v8_hvt ad=0.26 pd=2.52 as=0.26 ps=2.52 w=1 l=0.15
X4 a_267_47# C a_49_297# VPB sky130_fd_pr__pfet_01v8_hvt ad=0.265 pd=1.53 as=0.275 ps=1.55 w=1 l=0.15
X5 a_131_47# A a_49_47# VNB sky130_fd_pr__nfet_01v8 ad=0.17225 pd=1.18 as=0.169 ps=1.82 w=0.65 l=0.15
X6 a_543_297# A a_267_47# VPB sky130_fd_pr__pfet_01v8_hvt ad=0.145 pd=1.29 as=0.265 ps=1.53 w=1 l=0.15
X7 a_267_47# B a_131_47# VNB sky130_fd_pr__nfet_01v8 ad=0.17875 pd=1.2 as=0.17225 ps=1.18 w=0.65 l=0.15
X8 VGND A a_49_47# VNB sky130_fd_pr__nfet_01v8 ad=0.09425 pd=0.94 as=0.17225 ps=1.18 w=0.65 l=0.15
X9 VPWR A a_49_297# VPB sky130_fd_pr__pfet_01v8_hvt ad=0.265 pd=1.53 as=0.26 ps=2.52 w=1 l=0.15
X10 a_49_297# B VPWR VPB sky130_fd_pr__pfet_01v8_hvt ad=0.275 pd=1.55 as=0.265 ps=1.53 w=1 l=0.15
X11 a_49_47# C a_267_47# VNB sky130_fd_pr__nfet_01v8 ad=0.17225 pd=1.18 as=0.17875 ps=1.2 w=0.65 l=0.15
C0 a_49_297# a_131_47# 0.00105f
C1 VGND a_267_47# 0.11076f
C2 a_543_297# B 0
C3 a_49_297# C 0.00121f
C4 A Y 0
C5 VPB a_49_297# 0.00816f
C6 a_49_47# B 0.15832f
C7 VPWR a_49_297# 0.0496f
C8 A a_543_297# 0
C9 A a_49_47# 0.08014f
C10 Y a_267_47# 0.03978f
C11 B a_131_47# 0.00363f
C12 a_543_297# a_267_47# 0.00584f
C13 B C 0.02891f
C14 VPB B 0.07428f
C15 a_49_47# a_267_47# 0.22106f
C16 A a_131_47# 0.00198f
C17 Y VGND 0.02418f
C18 VPWR B 0.03187f
C19 A C 0.04357f
C20 VPB A 0.06784f
C21 A VPWR 0.0295f
C22 a_49_297# B 0.01643f
C23 a_267_47# a_131_47# 0.02141f
C24 a_49_47# VGND 0.11144f
C25 a_267_47# C 0.02614f
C26 VPB a_267_47# 0.06538f
C27 A a_49_297# 0.02776f
C28 VPWR a_267_47# 0.08794f
C29 VGND a_131_47# 0.00578f
C30 a_543_297# Y 0
C31 a_49_47# Y 0.01308f
C32 VGND C 0.01396f
C33 a_267_47# a_49_297# 0.06795f
C34 VPB VGND 0.00815f
C35 VPWR VGND 0.01394f
C36 a_543_297# a_49_47# 0.01363f
C37 A B 0.16397f
C38 VGND a_49_297# 0.00143f
C39 Y C 0
C40 VPB Y 0.01106f
C41 a_267_47# B 0.13828f
C42 a_49_47# a_131_47# 0.0016f
C43 VPWR Y 0.01976f
C44 a_49_47# C 0.01389f
C45 a_543_297# VPWR 0.00899f
C46 VPB a_49_47# 0.04946f
C47 A a_267_47# 0.17237f
C48 a_49_47# VPWR 0.18475f
C49 VGND B 0.09581f
C50 a_49_47# a_49_297# 0.09931f
C51 A VGND 0.03097f
C52 VPB C 0.03236f
C53 VPWR C 0.01037f
C54 Y B 0.0015f
C55 VPB VPWR 0.14268f
C56 VGND VNB 0.6061f
C57 Y VNB 0.12788f
C58 VPWR VNB 0.51872f
C59 VPB VNB 0.95915f
C60 a_131_47# VNB 0.08237f
C61 a_49_47# VNB 0.22738f
C62 a_543_297# VNB 0.08022f
C63 a_49_297# VNB 0.04952f
C64 a_267_47# VNB 0.03423f
.ends
