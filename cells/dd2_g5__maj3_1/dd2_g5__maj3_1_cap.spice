* NGSPICE file created from dd2_g5__maj3_1.ext - technology: sky130A

.subckt dd2_g5__maj3_1 A B C VGND VNB VPB VPWR Y
X0 a_223_47# A a_141_47# VNB sky130_fd_pr__nfet_01v8 ad=0.17225 pd=1.18 as=0.169 ps=1.82 w=0.65 l=0.15
X1 a_359_47# B a_223_47# VNB sky130_fd_pr__nfet_01v8 ad=0.17875 pd=1.2 as=0.17225 ps=1.18 w=0.65 l=0.15
X2 VGND A a_141_47# VNB sky130_fd_pr__nfet_01v8 ad=0.09425 pd=0.94 as=0.17225 ps=1.18 w=0.65 l=0.15
X3 Y a_359_47# VGND VNB sky130_fd_pr__nfet_01v8 ad=0.169 pd=1.82 as=0.169 ps=1.82 w=0.65 l=0.15
X4 VPWR B a_635_297# VPB sky130_fd_pr__pfet_01v8_hvt ad=0.26 pd=2.52 as=0.145 ps=1.29 w=1 l=0.15
X5 a_141_47# C a_359_47# VNB sky130_fd_pr__nfet_01v8 ad=0.17225 pd=1.18 as=0.17875 ps=1.2 w=0.65 l=0.15
X6 Y a_359_47# VPWR VPB sky130_fd_pr__pfet_01v8_hvt ad=0.26 pd=2.52 as=0.26 ps=2.52 w=1 l=0.15
X7 a_359_47# C a_141_297# VPB sky130_fd_pr__pfet_01v8_hvt ad=0.265 pd=1.53 as=0.275 ps=1.55 w=1 l=0.15
X8 VPWR A a_141_297# VPB sky130_fd_pr__pfet_01v8_hvt ad=0.265 pd=1.53 as=0.26 ps=2.52 w=1 l=0.15
X9 a_141_47# B VGND VNB sky130_fd_pr__nfet_01v8 ad=0.169 pd=1.82 as=0.09425 ps=0.94 w=0.65 l=0.15
X10 a_635_297# A a_359_47# VPB sky130_fd_pr__pfet_01v8_hvt ad=0.145 pd=1.29 as=0.265 ps=1.53 w=1 l=0.15
X11 a_141_297# B VPWR VPB sky130_fd_pr__pfet_01v8_hvt ad=0.275 pd=1.55 as=0.265 ps=1.53 w=1 l=0.15
C0 a_141_47# a_141_297# 0.07304f
C1 A VGND 0.02498f
C2 VPB C 0.03242f
C3 VPWR C 0.0124f
C4 Y B 0.00119f
C5 VPB VPWR 0.18117f
C6 a_141_297# a_223_47# 0.00457f
C7 VGND a_359_47# 0.10623f
C8 a_635_297# B 0
C9 a_141_297# C 0.00783f
C10 A Y 0
C11 VPB a_141_297# 0.02188f
C12 a_141_47# B 0.14454f
C13 VPWR a_141_297# 0.12274f
C14 A a_635_297# 0
C15 A a_141_47# 0.06535f
C16 Y a_359_47# 0.04546f
C17 B a_223_47# 0
C18 a_635_297# a_359_47# 0.01504f
C19 B C 0.0378f
C20 VPB B 0.07551f
C21 a_141_47# a_359_47# 0.3791f
C22 A a_223_47# 0
C23 Y VGND 0.02363f
C24 VPWR B 0.03601f
C25 A C 0.03361f
C26 VPB A 0.07609f
C27 A VPWR 0.02858f
C28 a_141_297# B 0.02679f
C29 a_359_47# a_223_47# 0.0167f
C30 a_141_47# VGND 0.16606f
C31 a_359_47# C 0.01649f
C32 VPB a_359_47# 0.06228f
C33 A a_141_297# 0.05509f
C34 VPWR a_359_47# 0.12016f
C35 VGND a_223_47# 0.01273f
C36 a_635_297# Y 0
C37 a_141_47# Y 0.01876f
C38 VGND C 0.01372f
C39 a_359_47# a_141_297# 0.10655f
C40 VPB VGND 0.01857f
C41 VPWR VGND 0.01925f
C42 a_635_297# a_141_47# 0.00801f
C43 A B 0.16887f
C44 Y a_223_47# 0
C45 VGND a_141_297# 0.00471f
C46 Y C 0
C47 VPB Y 0.01962f
C48 a_359_47# B 0.11623f
C49 a_141_47# a_223_47# 0.00819f
C50 VPWR Y 0.03262f
C51 a_141_47# C 0.00899f
C52 a_635_297# VPWR 0.01293f
C53 VPB a_141_47# 0.04295f
C54 A a_359_47# 0.22992f
C55 a_141_47# VPWR 0.19575f
C56 VGND B 0.08976f
C57 VGND VNB 0.74199f
C58 Y VNB 0.18106f
C59 VPWR VNB 0.52746f
C60 VPB VNB 1.13634f
C61 a_223_47# VNB 0.16981f
C62 a_141_47# VNB 0.28845f
C63 a_141_297# VNB 0.03192f
.ends
