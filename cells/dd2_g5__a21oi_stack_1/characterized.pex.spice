* NGSPICE file created from dd2_g5__a21oi_stack_1.ext - technology: sky130A

.subckt dd2_g5__a21oi_stack_1 A B C VGND VNB VPB VPWR Y
X0 VPWR.t3 B.t3 a_45_297.t0 VPB.t0 sky130_fd_pr__pfet_01v8_hvt ad=0.135 pd=1.27 as=0.26 ps=2.52 w=1 l=0.15
X1 a_127_47.t2 A.t1 Y.t1 VNB.t2 sky130_fd_pr__nfet_01v8 ad=0.08775 pd=0.92 as=0.08775 ps=0.92 w=0.65 l=0.15
X2 a_45_297.t3 A.t2 VPWR.t1 VPB.t3 sky130_fd_pr__pfet_01v8_hvt ad=0.26 pd=2.52 as=0.135 ps=1.27 w=1 l=0.15
X3 VPWR.t0 A.t3 a_45_297.t2 VPB.t2 sky130_fd_pr__pfet_01v8_hvt ad=0.135 pd=1.27 as=0.135 ps=1.27 w=1 l=0.15
X4 a_127_47.t0 B.t1 VGND.t2 VNB.t0 sky130_fd_pr__nfet_01v8 ad=0.08775 pd=0.92 as=0.169 ps=1.82 w=0.65 l=0.15
X5 Y.t4 C.t0 VGND.t0 VNB.t4 sky130_fd_pr__nfet_01v8 ad=0.08775 pd=0.92 as=0.22425 ps=1.34 w=0.65 l=0.15
X6 Y.t3 A.t0 a_127_47.t3 VNB.t3 sky130_fd_pr__nfet_01v8 ad=0.169 pd=1.82 as=0.08775 ps=0.92 w=0.65 l=0.15
X7 a_45_297.t5 C.t1 Y.t2 VPB.t5 sky130_fd_pr__pfet_01v8_hvt ad=0.135 pd=1.27 as=0.135 ps=1.27 w=1 l=0.15
X8 Y.t0 C.t2 a_45_297.t4 VPB.t4 sky130_fd_pr__pfet_01v8_hvt ad=0.135 pd=1.27 as=0.135 ps=1.27 w=1 l=0.15
X9 a_45_297.t1 B.t2 VPWR.t2 VPB.t1 sky130_fd_pr__pfet_01v8_hvt ad=0.135 pd=1.27 as=0.135 ps=1.27 w=1 l=0.15
X10 VGND.t1 B.t0 a_127_47.t1 VNB.t1 sky130_fd_pr__nfet_01v8 ad=0.22425 pd=1.34 as=0.08775 ps=0.92 w=0.65 l=0.15
R0 VGND.n2 VGND.t2 282.817
R1 VGND.n1 VGND.n0 205.079
R2 VGND.n0 VGND.t0 102.463
R3 VGND.n0 VGND.t1 24.9236
R4 VGND.n2 VGND.n1 5.87173
R5 VGND.n2 VGND 5.53564
R6 VGND VGND.n2 3.10353
R7 VGND.n1 VGND 0.552921
R8 Y.n3 Y.n2 585
R9 Y.n1 Y.t3 268.077
R10 Y.n1 Y.n0 248.248
R11 Y.n3 Y.n1 156.673
R12 Y.n4 Y 96.0005
R13 Y.n2 Y.t0 26.5955
R14 Y.n2 Y.t2 26.5955
R15 Y.n0 Y.t4 24.9236
R16 Y.n0 Y.t1 24.9236
R17 Y.n4 Y.n3 4.57193
R18 Y Y.n4 0.305262
R19 VPWR.n4 VPWR.n3 617.34
R20 VPWR.n2 VPWR.n1 607.212
R21 VPWR.n4 VPWR.n2 36.1333
R22 VPWR.n7 VPWR.n0 34.6358
R23 VPWR.n3 VPWR.t0 26.5955
R24 VPWR.n3 VPWR.t1 26.5955
R25 VPWR.n1 VPWR.t3 26.5955
R26 VPWR.n1 VPWR.t2 26.5955
R27 VPWR.n7 VPWR.n6 9.3005
R28 VPWR.n5 VPWR.n0 9.3005
R29 VPWR VPWR.n7 6.77697
R30 VPWR.n2 VPWR.n0 6.02403
R31 VPWR.n5 VPWR.n4 0.226787
R32 VPWR.n6 VPWR.n5 0.120292
R33 VPWR.n6 VPWR 0.0239375
R34 A.n1 A.t3 212.081
R35 A.n0 A.t2 212.081
R36 A A.n1 155.103
R37 A.n1 A.t1 139.78
R38 A.n0 A.t0 139.78
R39 A.n1 A.n0 61.346
R40 C.n1 C.t2 264.663
R41 C.n0 C.t1 212.081
R42 C C.n1 155.103
R43 C.n0 C.t0 139.78
R44 C.n1 C.n0 8.76414
R45 B.n1 B.t3 212.081
R46 B.n0 B.t2 212.081
R47 B B.n1 155.103
R48 B.n1 B.t1 139.78
R49 B.n0 B.t0 139.78
R50 B.n1 B.n0 61.346
R51 VPB.t2 VPB.t3 248.599
R52 VPB.t5 VPB.t2 248.599
R53 VPB.t4 VPB.t5 248.599
R54 VPB.t1 VPB.t4 248.599
R55 VPB.t0 VPB.t1 248.599
R56 VPB VPB.t0 248.599
R57 VNB.t1 VNB.t4 2392.23
R58 VNB.t2 VNB.t3 1196.12
R59 VNB.t4 VNB.t2 1196.12
R60 VNB.t0 VNB.t1 1196.12
R61 VNB VNB.t0 1196.12
R62 a_127_47.n1 a_127_47.n0 495.784
R63 a_127_47.n0 a_127_47.t3 24.9236
R64 a_127_47.n0 a_127_47.t2 24.9236
R65 a_127_47.t1 a_127_47.n1 24.9236
R66 a_127_47.n1 a_127_47.t0 24.9236
R67 a_45_297.n1 a_45_297.t3 370.784
R68 a_45_297.n1 a_45_297.n0 292.5
R69 a_45_297.n3 a_45_297.n2 289.519
R70 a_45_297.n2 a_45_297.t0 285.438
R71 a_45_297.n2 a_45_297.n1 76.7872
R72 a_45_297.n0 a_45_297.t2 26.5955
R73 a_45_297.n0 a_45_297.t5 26.5955
R74 a_45_297.n3 a_45_297.t4 26.5955
R75 a_45_297.t1 a_45_297.n3 26.5955
C0 Y C 0.02572f
C1 B VGND 0.0388f
C2 Y VPWR 0.01945f
C3 VGND A 0.01762f
C4 VPB VGND 0.01086f
C5 B C 0.02932f
C6 B VPWR 0.03341f
C7 C A 0.03922f
C8 C VPB 0.05081f
C9 A VPWR 0.02907f
C10 VPB VPWR 0.09056f
C11 B Y 0
C12 Y A 0.07538f
C13 Y VPB 0.01095f
C14 C VGND 0.017f
C15 VGND VPWR 0.03621f
C16 B VPB 0.05848f
C17 C VPWR 0.02514f
C18 VPB A 0.05821f
C19 Y VGND 0.08639f
C20 VGND VNB 0.56819f
C21 Y VNB 0.06976f
C22 VPWR VNB 0.3445f
C23 A VNB 0.15023f
C24 C VNB 0.11303f
C25 B VNB 0.16743f
C26 VPB VNB 0.73985f
C27 a_45_297.t4 VNB 0.04097f
C28 a_45_297.t3 VNB 0.07844f
C29 a_45_297.t2 VNB 0.0349f
C30 a_45_297.t5 VNB 0.03677f
C31 a_45_297.n0 VNB 0.02814f
C32 a_45_297.n1 VNB 0.09289f
C33 a_45_297.t0 VNB 0.08411f
C34 a_45_297.n2 VNB 0.10436f
C35 a_45_297.n3 VNB 0.02802f
C36 a_45_297.t1 VNB 0.03205f
C37 a_127_47.t0 VNB 0.02655f
C38 a_127_47.t3 VNB 0.02854f
C39 a_127_47.t2 VNB 0.02854f
C40 a_127_47.n0 VNB 0.08236f
C41 a_127_47.n1 VNB 0.08216f
C42 a_127_47.t1 VNB 0.02655f
C43 VPB.t3 VNB 0.08264f
C44 VPB.t2 VNB 0.03616f
C45 VPB.t5 VNB 0.03616f
C46 VPB.t4 VNB 0.03616f
C47 VPB.t1 VNB 0.03616f
C48 VPB.t0 VNB 0.03616f
C49 B.n0 VNB 0.04414f
C50 B.n1 VNB 0.04931f
C51 C.n0 VNB 0.03692f
C52 C.n1 VNB 0.05603f
C53 A.n0 VNB 0.05111f
C54 A.n1 VNB 0.0571f
C55 VPWR.n0 VNB 0.00702f
C56 VPWR.t2 VNB 0.02836f
C57 VPWR.t3 VNB 0.02836f
C58 VPWR.n1 VNB 0.02094f
C59 VPWR.n2 VNB 0.02039f
C60 VPWR.t1 VNB 0.03121f
C61 VPWR.t0 VNB 0.03121f
C62 VPWR.n3 VNB 0.02142f
C63 VPWR.n4 VNB 0.16663f
C64 VPWR.n5 VNB 0.10314f
C65 VPWR.n6 VNB 0.02019f
C66 VPWR.n7 VNB 0.00715f
C67 Y.t3 VNB 0.05853f
C68 Y.t1 VNB 0.02747f
C69 Y.t4 VNB 0.02878f
C70 Y.n0 VNB 0.03308f
C71 Y.n1 VNB 0.11589f
C72 Y.t2 VNB 0.04251f
C73 Y.t0 VNB 0.04671f
C74 Y.n2 VNB 0.03949f
C75 Y.n3 VNB 0.06324f
C76 Y.n4 VNB 0.00681f
C77 VGND.t0 VNB 0.03382f
C78 VGND.t1 VNB 0.01699f
C79 VGND.n0 VNB 0.02367f
C80 VGND.n1 VNB 0.04728f
C81 VGND.t2 VNB 0.02807f
C82 VGND.n2 VNB 0.02288f
.ends
