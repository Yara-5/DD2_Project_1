* dd2_g5__a21oi_stack_1: Y = !C & (!A | !B)
* Generated by synthesize.py; stages in signal order:
*   Y = !(C | (A & B))
.subckt dd2_g5__a21oi_stack_1 A B C VGND VNB VPB VPWR Y
XN1 Y C VGND VNB sky130_fd_pr__nfet_01v8 w=0.65 l=0.15
XN2 Y A Y_d1 VNB sky130_fd_pr__nfet_01v8 w=1.3 l=0.15
XN3 Y_d1 B VGND VNB sky130_fd_pr__nfet_01v8 w=1.3 l=0.15
XP1 Y_u1 C VPWR VPB sky130_fd_pr__pfet_01v8_hvt w=2 l=0.15
XP2 Y A Y_u1 VPB sky130_fd_pr__pfet_01v8_hvt w=2 l=0.15
XP3 Y B Y_u1 VPB sky130_fd_pr__pfet_01v8_hvt w=2 l=0.15
.ends dd2_g5__a21oi_stack_1
