* dd2_g5__nor3_stack_1: Y = !A & !B & !C
* Generated by synthesize.py; stages in signal order:
*   Y = !(A | B | C)
.subckt dd2_g5__nor3_stack_1 A B C VGND VNB VPB VPWR Y
XN1 Y A VGND VNB sky130_fd_pr__nfet_01v8 w=0.65 l=0.15
XN2 Y B VGND VNB sky130_fd_pr__nfet_01v8 w=0.65 l=0.15
XN3 Y C VGND VNB sky130_fd_pr__nfet_01v8 w=0.65 l=0.15
XP1 Y_u1 A VPWR VPB sky130_fd_pr__pfet_01v8_hvt w=3 l=0.15
XP2 Y_u2 B Y_u1 VPB sky130_fd_pr__pfet_01v8_hvt w=3 l=0.15
XP3 Y C Y_u2 VPB sky130_fd_pr__pfet_01v8_hvt w=3 l=0.15
.ends dd2_g5__nor3_stack_1
