* NGSPICE file created from dd2_g5__nor3_stack_1.ext - technology: sky130A

.subckt dd2_g5__nor3_stack_1 A B C VGND VNB VPB VPWR Y
X0 Y.t4 B.t0 VGND.t1 VNB.t2 sky130_fd_pr__nfet_01v8 ad=0.36075 pd=1.76 as=0.08775 ps=0.92 w=0.65 l=0.15
X1 a_139_297.t0 A.t3 VPWR.t0 VPB.t0 sky130_fd_pr__pfet_01v8_hvt ad=0.135 pd=1.27 as=0.26 ps=2.52 w=1 l=0.15
X2 Y.t1 C.t3 a_391_297.t0 VPB.t3 sky130_fd_pr__pfet_01v8_hvt ad=0.135 pd=1.27 as=0.135 ps=1.27 w=1 l=0.15
X3 VGND.t2 A.t0 Y.t5 VNB.t0 sky130_fd_pr__nfet_01v8 ad=0.08775 pd=0.92 as=0.169 ps=1.82 w=0.65 l=0.15
X4 VGND.t0 C.t0 Y.t2 VNB.t1 sky130_fd_pr__nfet_01v8 ad=0.169 pd=1.82 as=0.36075 ps=1.76 w=0.65 l=0.15
X5 a_391_297.t3 B.t1 a_139_297.t5 VPB.t8 sky130_fd_pr__pfet_01v8_hvt ad=0.135 pd=1.27 as=0.135 ps=1.27 w=1 l=0.15
X6 a_139_297.t4 B.t2 a_391_297.t5 VPB.t7 sky130_fd_pr__pfet_01v8_hvt ad=0.135 pd=1.27 as=0.135 ps=1.27 w=1 l=0.15
X7 a_391_297.t4 B.t3 a_139_297.t3 VPB.t6 sky130_fd_pr__pfet_01v8_hvt ad=0.135 pd=1.27 as=0.135 ps=1.27 w=1 l=0.15
X8 a_139_297.t2 A.t1 VPWR.t2 VPB.t2 sky130_fd_pr__pfet_01v8_hvt ad=0.135 pd=1.27 as=0.135 ps=1.27 w=1 l=0.15
X9 VPWR.t1 A.t2 a_139_297.t1 VPB.t1 sky130_fd_pr__pfet_01v8_hvt ad=0.135 pd=1.27 as=0.135 ps=1.27 w=1 l=0.15
X10 Y.t0 C.t1 a_391_297.t2 VPB.t5 sky130_fd_pr__pfet_01v8_hvt ad=0.26 pd=2.52 as=0.135 ps=1.27 w=1 l=0.15
X11 a_391_297.t1 C.t2 Y.t3 VPB.t4 sky130_fd_pr__pfet_01v8_hvt ad=0.135 pd=1.27 as=0.135 ps=1.27 w=1 l=0.15
R0 VGND.n1 VGND.t0 288.76
R1 VGND.n3 VGND.n2 199.739
R2 VGND.n8 VGND.n0 34.6358
R3 VGND.n4 VGND.n0 34.6358
R4 VGND.n4 VGND.n3 26.7299
R5 VGND.n2 VGND.t2 24.9236
R6 VGND.n2 VGND.t1 24.9236
R7 VGND.n5 VGND.n4 9.3005
R8 VGND.n6 VGND.n0 9.3005
R9 VGND.n8 VGND.n7 9.3005
R10 VGND VGND.n8 6.77697
R11 VGND.n3 VGND.n1 6.75255
R12 VGND.n5 VGND.n1 0.179626
R13 VGND.n7 VGND.n6 0.120292
R14 VGND.n6 VGND.n5 0.120292
R15 VGND.n7 VGND 0.0239375
R16 Y.n1 Y.n0 340.596
R17 Y.n1 Y.t0 219.137
R18 Y.n4 Y.t5 209.923
R19 Y.n3 Y.n1 207.304
R20 Y.n3 Y.n2 185
R21 Y.n2 Y.t2 180
R22 Y.n4 Y.n3 63.2476
R23 Y.n0 Y.t1 26.5955
R24 Y.n0 Y.t3 26.5955
R25 Y.n2 Y.t4 24.9236
R26 Y.n4 Y 7.31479
R27 Y Y.n4 6.02403
R28 VPWR.n2 VPWR.n1 616.742
R29 VPWR.n0 VPWR.t0 257.474
R30 VPWR.n2 VPWR.n0 27.5597
R31 VPWR.n1 VPWR.t1 26.5955
R32 VPWR.n1 VPWR.t2 26.5955
R33 VPWR.n4 VPWR.n0 13.5534
R34 VPWR.n4 VPWR.n3 9.3005
R35 VPWR VPWR.n4 6.77697
R36 VPWR.n3 VPWR.n2 1.27097
R37 VPWR.n3 VPWR 0.0239375
R38 C.n0 C.t1 273.425
R39 C.n1 C.t3 212.081
R40 C.n0 C.t2 212.081
R41 C C.n1 155.103
R42 C.n1 C.t0 139.78
R43 C.n1 C.n0 61.346
R44 B.n0 B.t1 273.425
R45 B.n1 B.t3 212.081
R46 B.n0 B.t2 212.081
R47 B B.n1 155.103
R48 B.n1 B.t0 139.78
R49 B.n1 B.n0 61.346
R50 A.n1 A.t3 273.425
R51 A.n0 A.t1 212.081
R52 A.n1 A.t2 212.081
R53 A A.n2 155.103
R54 A.n0 A.t0 139.78
R55 A.n2 A.n1 52.5823
R56 A.n2 A.n0 8.76414
R57 VPB VPB.t0 284.113
R58 VPB.t4 VPB.t5 248.599
R59 VPB.t3 VPB.t4 248.599
R60 VPB.t8 VPB.t3 248.599
R61 VPB.t7 VPB.t8 248.599
R62 VPB.t6 VPB.t7 248.599
R63 VPB.t2 VPB.t6 248.599
R64 VPB.t1 VPB.t2 248.599
R65 VPB.t0 VPB.t1 248.599
R66 VNB VNB.t0 3759.22
R67 VNB.t2 VNB.t1 3588.35
R68 VNB.t0 VNB.t2 1196.12
R69 a_391_297.n3 a_391_297.n2 648.247
R70 a_391_297.n2 a_391_297.n1 648.247
R71 a_391_297.n2 a_391_297.n0 297.224
R72 a_391_297.n1 a_391_297.t5 26.5955
R73 a_391_297.n1 a_391_297.t4 26.5955
R74 a_391_297.n0 a_391_297.t0 26.5955
R75 a_391_297.n0 a_391_297.t3 26.5955
R76 a_391_297.t2 a_391_297.n3 26.5955
R77 a_391_297.n3 a_391_297.t1 26.5955
R78 a_139_297.n2 a_139_297.n0 347.06
R79 a_139_297.n2 a_139_297.n1 253.114
R80 a_139_297.n3 a_139_297.n2 189.28
R81 a_139_297.n1 a_139_297.t1 26.5955
R82 a_139_297.n1 a_139_297.t0 26.5955
R83 a_139_297.n0 a_139_297.t5 26.5955
R84 a_139_297.n0 a_139_297.t4 26.5955
R85 a_139_297.n3 a_139_297.t3 26.5955
R86 a_139_297.t2 a_139_297.n3 26.5955
C0 Y VPWR 0.0798f
C1 B VPWR 0.02962f
C2 Y VPB 0.02417f
C3 B VPB 0.08464f
C4 VGND A 0.02755f
C5 Y C 0.11011f
C6 B C 0.03373f
C7 VGND VPWR 0.05126f
C8 VGND VPB 0.01632f
C9 VPWR A 0.05433f
C10 B Y 0.03667f
C11 VGND C 0.02523f
C12 VPB A 0.08738f
C13 VPB VPWR 0.12468f
C14 VGND Y 0.15198f
C15 B VGND 0.02468f
C16 C VPWR 0.02985f
C17 C VPB 0.0899f
C18 Y A 0.02134f
C19 B A 0.03922f
C20 VGND VNB 0.60412f
C21 Y VNB 0.1141f
C22 VPWR VNB 0.49369f
C23 C VNB 0.18987f
C24 B VNB 0.16325f
C25 A VNB 0.18593f
C26 VPB VNB 1.00969f
C27 a_139_297.t3 VNB 0.03709f
C28 a_139_297.t5 VNB 0.04185f
C29 a_139_297.t4 VNB 0.03709f
C30 a_139_297.n0 VNB 0.04069f
C31 a_139_297.t1 VNB 0.03522f
C32 a_139_297.t0 VNB 0.03957f
C33 a_139_297.n1 VNB 0.05103f
C34 a_139_297.n2 VNB 0.18452f
C35 a_139_297.n3 VNB 0.03157f
C36 a_139_297.t2 VNB 0.03522f
C37 a_391_297.t1 VNB 0.03727f
C38 a_391_297.t0 VNB 0.03727f
C39 a_391_297.t3 VNB 0.04229f
C40 a_391_297.n0 VNB 0.03282f
C41 a_391_297.t5 VNB 0.03752f
C42 a_391_297.t4 VNB 0.03752f
C43 a_391_297.n1 VNB 0.03509f
C44 a_391_297.n2 VNB 0.10339f
C45 a_391_297.n3 VNB 0.03509f
C46 a_391_297.t2 VNB 0.04197f
C47 VPB.t5 VNB 0.09044f
C48 VPB.t4 VNB 0.03724f
C49 VPB.t3 VNB 0.03724f
C50 VPB.t8 VNB 0.03724f
C51 VPB.t7 VNB 0.03724f
C52 VPB.t6 VNB 0.03724f
C53 VPB.t2 VNB 0.03724f
C54 VPB.t1 VNB 0.03724f
C55 VPB.t0 VNB 0.0399f
C56 A.n0 VNB 0.03152f
C57 A.n1 VNB 0.07816f
C58 A.n2 VNB 0.01893f
C59 B.n0 VNB 0.0886f
C60 B.n1 VNB 0.05823f
C61 C.n0 VNB 0.08753f
C62 C.n1 VNB 0.05753f
C63 VPWR.t0 VNB 0.06537f
C64 VPWR.n0 VNB 0.03852f
C65 VPWR.t2 VNB 0.03008f
C66 VPWR.t1 VNB 0.03008f
C67 VPWR.n1 VNB 0.02204f
C68 VPWR.n2 VNB 0.08033f
C69 VPWR.n3 VNB 0.3715f
C70 VPWR.n4 VNB 0.00362f
C71 Y.t0 VNB 0.07493f
C72 Y.t3 VNB 0.03501f
C73 Y.t1 VNB 0.03501f
C74 Y.n0 VNB 0.03479f
C75 Y.n1 VNB 0.15667f
C76 Y.t2 VNB 0.08031f
C77 Y.t4 VNB 0.024f
C78 Y.n2 VNB 0.07464f
C79 Y.n3 VNB 0.07342f
C80 Y.t5 VNB 0.04551f
C81 Y.n4 VNB 0.02358f
C82 VGND.n0 VNB 0.00687f
C83 VGND.t0 VNB 0.02909f
C84 VGND.n1 VNB 0.16332f
C85 VGND.t1 VNB 0.01878f
C86 VGND.t2 VNB 0.01747f
C87 VGND.n2 VNB 0.00829f
C88 VGND.n3 VNB 0.02168f
C89 VGND.n4 VNB 0.00608f
C90 VGND.n5 VNB 0.04087f
C91 VGND.n6 VNB 0.01939f
C92 VGND.n7 VNB 0.01159f
C93 VGND.n8 VNB 0.0041f
.ends
