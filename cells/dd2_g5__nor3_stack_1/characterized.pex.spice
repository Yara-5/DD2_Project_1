* NGSPICE file created from dd2_g5__nor3_stack_1.ext - technology: sky130A

.subckt dd2_g5__nor3_stack_1 A B C VGND VNB VPB VPWR Y
X0 Y.t5 A.t2 a_153_297.t1 VPB.t1 sky130_fd_pr__pfet_01v8_hvt ad=0.265 pd=1.53 as=0.275 ps=1.55 w=1 l=0.15
X1 a_153_297.t4 B.t2 a_293_297.t4 VPB.t7 sky130_fd_pr__pfet_01v8_hvt ad=0.275 pd=1.55 as=0.265 ps=1.53 w=1 l=0.15
X2 a_293_297.t1 C.t2 VPWR.t0 VPB.t4 sky130_fd_pr__pfet_01v8_hvt ad=0.265 pd=1.53 as=0.275 ps=1.55 w=1 l=0.15
X3 a_293_297.t5 B.t3 a_153_297.t3 VPB.t6 sky130_fd_pr__pfet_01v8_hvt ad=0.265 pd=1.53 as=0.275 ps=1.55 w=1 l=0.15
X4 VPWR.t1 C.t3 a_293_297.t0 VPB.t3 sky130_fd_pr__pfet_01v8_hvt ad=0.275 pd=1.55 as=0.265 ps=1.53 w=1 l=0.15
X5 Y.t2 B.t0 VGND.t1 VNB.t2 sky130_fd_pr__nfet_01v8 ad=0.17225 pd=1.18 as=0.17875 ps=1.2 w=0.65 l=0.15
X6 VGND.t0 C.t0 Y.t0 VNB.t1 sky130_fd_pr__nfet_01v8 ad=0.169 pd=1.82 as=0.17225 ps=1.18 w=0.65 l=0.15
X7 a_153_297.t0 A.t3 Y.t4 VPB.t0 sky130_fd_pr__pfet_01v8_hvt ad=0.275 pd=1.55 as=0.26 ps=2.52 w=1 l=0.15
X8 a_293_297.t3 B.t1 a_153_297.t5 VPB.t8 sky130_fd_pr__pfet_01v8_hvt ad=0.265 pd=1.53 as=0.275 ps=1.55 w=1 l=0.15
X9 VGND.t2 A.t0 Y.t3 VNB.t0 sky130_fd_pr__nfet_01v8 ad=0.17875 pd=1.2 as=0.169 ps=1.82 w=0.65 l=0.15
X10 a_153_297.t2 A.t1 Y.t1 VPB.t2 sky130_fd_pr__pfet_01v8_hvt ad=0.275 pd=1.55 as=0.265 ps=1.53 w=1 l=0.15
X11 VPWR.t2 C.t1 a_293_297.t2 VPB.t5 sky130_fd_pr__pfet_01v8_hvt ad=0.26 pd=2.52 as=0.265 ps=1.53 w=1 l=0.15
R0 VGND.n3 VGND.t0 289.015
R1 VGND.n2 VGND.n1 199.739
R2 VGND.n1 VGND.t2 50.7697
R3 VGND.n1 VGND.t1 50.7697
R4 VGND.n6 VGND.n0 34.6358
R5 VGND.n2 VGND.n0 13.9299
R6 VGND.n4 VGND.n0 9.3005
R7 VGND.n6 VGND.n5 9.3005
R8 VGND.n3 VGND.n2 7.27373
R9 VGND VGND.n6 6.77697
R10 VGND.n4 VGND.n3 0.326823
R11 VGND.n5 VGND.n4 0.120292
R12 VGND.n5 VGND 0.0239375
R13 VPWR.n4 VPWR.t2 889.91
R14 VPWR.n3 VPWR.n2 607.212
R15 VPWR.n2 VPWR.t1 54.1755
R16 VPWR.n2 VPWR.t0 54.1755
R17 VPWR.n12 VPWR.n0 34.6358
R18 VPWR.n8 VPWR.n0 34.6358
R19 VPWR.n8 VPWR.n7 34.6358
R20 VPWR.n7 VPWR.n6 34.6358
R21 VPWR.n6 VPWR.n3 26.3534
R22 VPWR.n4 VPWR.n3 15.8835
R23 VPWR.n12 VPWR.n11 9.3005
R24 VPWR.n10 VPWR.n0 9.3005
R25 VPWR.n9 VPWR.n8 9.3005
R26 VPWR.n7 VPWR.n1 9.3005
R27 VPWR.n6 VPWR.n5 9.3005
R28 VPWR VPWR.n12 6.77697
R29 VPWR.n5 VPWR.n4 0.147193
R30 VPWR.n11 VPWR.n10 0.120292
R31 VPWR.n10 VPWR.n9 0.120292
R32 VPWR.n9 VPWR.n1 0.120292
R33 VPWR.n5 VPWR.n1 0.120292
R34 VPWR.n11 VPWR 0.0239375
R35 Y.n3 Y.t4 892.79
R36 Y.n2 Y.n0 617.529
R37 Y.n4 Y.t3 209.988
R38 Y.n2 Y.n1 194.74
R39 Y.n0 Y.t5 52.2055
R40 Y.n0 Y.t1 52.2055
R41 Y.n1 Y.t2 48.9236
R42 Y.n1 Y.t0 48.9236
R43 Y.n3 Y.n2 36.7213
R44 Y.n5 Y 6.4005
R45 Y Y.n5 3.2005
R46 Y.n4 Y.n3 2.03193
R47 Y.n5 Y.n4 0.146067
R48 C.n0 C.t1 732.226
R49 C.n0 C.t2 393.536
R50 C.n1 C.t3 241.536
R51 C.n1 C.t0 169.237
R52 C.n2 C.n1 152
R53 C.n2 C.n0 51.9534
R54 C C.n2 6.02403
R55 B.n1 B.t1 576.832
R56 B.n1 B.t2 393.536
R57 B.n0 B.t3 241.536
R58 B.n0 B.t0 169.237
R59 B B.n0 157.69
R60 B B.n1 48.2257
R61 A.n0 A.t1 445.488
R62 A.n0 A.t2 393.536
R63 A.n1 A.t3 241.536
R64 A.n1 A.t0 169.237
R65 A.n2 A.n1 152
R66 A.n2 A.n0 53.6025
R67 A A.n2 6.02403
R68 VPB.t2 VPB.t8 414.33
R69 VPB.t7 VPB.t1 414.33
R70 VPB.t3 VPB.t4 414.33
R71 VPB.t0 VPB.t6 414.33
R72 VPB.t8 VPB.t5 402.493
R73 VPB.t1 VPB.t2 402.493
R74 VPB.t4 VPB.t7 402.493
R75 VPB.t6 VPB.t3 402.493
R76 VPB VPB.t0 325.546
R77 VNB.t0 VNB.t2 1993.53
R78 VNB.t2 VNB.t1 1936.57
R79 VNB VNB.t0 1566.34
R80 a_293_297.n3 a_293_297.n2 698.833
R81 a_293_297.n2 a_293_297.n0 678.062
R82 a_293_297.n2 a_293_297.n1 585
R83 a_293_297.n1 a_293_297.t4 52.2055
R84 a_293_297.n1 a_293_297.t1 52.2055
R85 a_293_297.n0 a_293_297.t0 52.2055
R86 a_293_297.n0 a_293_297.t5 52.2055
R87 a_293_297.t2 a_293_297.n3 52.2055
R88 a_293_297.n3 a_293_297.t3 52.2055
R89 a_153_297.n2 a_153_297.n0 750.996
R90 a_153_297.n3 a_153_297.n2 688.907
R91 a_153_297.n2 a_153_297.n1 585
R92 a_153_297.n1 a_153_297.t1 54.1755
R93 a_153_297.n1 a_153_297.t4 54.1755
R94 a_153_297.n0 a_153_297.t3 54.1755
R95 a_153_297.n0 a_153_297.t0 54.1755
R96 a_153_297.n3 a_153_297.t5 54.1755
R97 a_153_297.t2 a_153_297.n3 54.1755
C0 VPWR B 0.03048f
C1 Y B 0.18099f
C2 VGND B 0.03095f
C3 A B 0.24622f
C4 Y VPWR 0.0229f
C5 VGND VPWR 0.02979f
C6 C VPB 0.10272f
C7 A VPWR 0.04152f
C8 Y VGND 0.25098f
C9 Y A 0.16483f
C10 VGND A 0.02475f
C11 C B 0.21993f
C12 VPB B 0.10174f
C13 C VPWR 0.04378f
C14 VPB VPWR 0.18194f
C15 Y C 0.06483f
C16 Y VPB 0.03573f
C17 VGND C 0.22828f
C18 C A 0.0328f
C19 VGND VPB 0.01624f
C20 A VPB 0.12328f
C21 VGND VNB 0.82714f
C22 VPWR VNB 0.65347f
C23 Y VNB 0.14274f
C24 C VNB 0.32887f
C25 B VNB 0.39778f
C26 A VNB 0.22816f
C27 VPB VNB 1.45409f
C28 a_153_297.t5 VNB 0.11027f
C29 a_153_297.t3 VNB 0.07547f
C30 a_153_297.t0 VNB 0.07564f
C31 a_153_297.n0 VNB 0.11813f
C32 a_153_297.t1 VNB 0.08693f
C33 a_153_297.t4 VNB 0.08669f
C34 a_153_297.n1 VNB 0.08253f
C35 a_153_297.n2 VNB 0.31476f
C36 a_153_297.n3 VNB 0.08911f
C37 a_153_297.t2 VNB 0.09165f
C38 a_293_297.t3 VNB 0.10748f
C39 a_293_297.t0 VNB 0.06765f
C40 a_293_297.t5 VNB 0.07267f
C41 a_293_297.n0 VNB 0.08565f
C42 a_293_297.t4 VNB 0.0839f
C43 a_293_297.t1 VNB 0.07723f
C44 a_293_297.n1 VNB 0.07695f
C45 a_293_297.n2 VNB 0.35125f
C46 a_293_297.n3 VNB 0.09064f
C47 a_293_297.t2 VNB 0.12254f
C48 VPB.t5 VNB 0.10478f
C49 VPB.t8 VNB 0.05926f
C50 VPB.t2 VNB 0.05926f
C51 VPB.t1 VNB 0.05926f
C52 VPB.t7 VNB 0.05926f
C53 VPB.t4 VNB 0.05926f
C54 VPB.t3 VNB 0.05926f
C55 VPB.t6 VNB 0.05926f
C56 VPB.t0 VNB 0.05368f
C57 A.n0 VNB 0.25739f
C58 A.n1 VNB 0.06883f
C59 A.n2 VNB 0.20226f
C60 B.n0 VNB 0.06906f
C61 B.n1 VNB 0.34339f
C62 C.n0 VNB 0.3313f
C63 C.n1 VNB 0.05841f
C64 C.n2 VNB 0.03539f
C65 Y.t3 VNB 0.07251f
C66 Y.t1 VNB 0.09135f
C67 Y.t5 VNB 0.08663f
C68 Y.n0 VNB 0.08366f
C69 Y.t0 VNB 0.04772f
C70 Y.t2 VNB 0.05135f
C71 Y.n1 VNB 0.0547f
C72 Y.n2 VNB 0.33324f
C73 Y.t4 VNB 0.11006f
C74 Y.n3 VNB 0.09589f
C75 Y.n4 VNB 0.00807f
C76 Y.n5 VNB 0.00779f
C77 VPWR.n0 VNB 0.01231f
C78 VPWR.n1 VNB 0.03476f
C79 VPWR.t0 VNB 0.0604f
C80 VPWR.t1 VNB 0.05082f
C81 VPWR.n2 VNB 0.0436f
C82 VPWR.n3 VNB 0.0231f
C83 VPWR.t2 VNB 0.12186f
C84 VPWR.n4 VNB 0.46872f
C85 VPWR.n5 VNB 0.04258f
C86 VPWR.n6 VNB 0.01084f
C87 VPWR.n7 VNB 0.01231f
C88 VPWR.n8 VNB 0.01231f
C89 VPWR.n9 VNB 0.03476f
C90 VPWR.n10 VNB 0.03476f
C91 VPWR.n11 VNB 0.02078f
C92 VPWR.n12 VNB 0.00736f
C93 VGND.n0 VNB 0.00626f
C94 VGND.t1 VNB 0.03492f
C95 VGND.t2 VNB 0.03505f
C96 VGND.n1 VNB 0.02116f
C97 VGND.n2 VNB 0.0272f
C98 VGND.t0 VNB 0.03987f
C99 VGND.n3 VNB 0.2227f
C100 VGND.n4 VNB 0.24984f
C101 VGND.n5 VNB 0.01506f
C102 VGND.n6 VNB 0.00533f
.ends
