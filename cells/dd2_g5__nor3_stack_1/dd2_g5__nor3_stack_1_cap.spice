* NGSPICE file created from dd2_g5__nor3_stack_1.ext - technology: sky130A

.subckt dd2_g5__nor3_stack_1 A B C VGND VNB VPB VPWR Y
X0 Y B VGND VNB sky130_fd_pr__nfet_01v8 ad=0.36075 pd=1.76 as=0.08775 ps=0.92 w=0.65 l=0.15
X1 a_139_297# A VPWR VPB sky130_fd_pr__pfet_01v8_hvt ad=0.135 pd=1.27 as=0.26 ps=2.52 w=1 l=0.15
X2 Y C a_391_297# VPB sky130_fd_pr__pfet_01v8_hvt ad=0.135 pd=1.27 as=0.135 ps=1.27 w=1 l=0.15
X3 VGND A Y VNB sky130_fd_pr__nfet_01v8 ad=0.08775 pd=0.92 as=0.169 ps=1.82 w=0.65 l=0.15
X4 VGND C Y VNB sky130_fd_pr__nfet_01v8 ad=0.169 pd=1.82 as=0.36075 ps=1.76 w=0.65 l=0.15
X5 a_391_297# B a_139_297# VPB sky130_fd_pr__pfet_01v8_hvt ad=0.135 pd=1.27 as=0.135 ps=1.27 w=1 l=0.15
X6 a_139_297# B a_391_297# VPB sky130_fd_pr__pfet_01v8_hvt ad=0.135 pd=1.27 as=0.135 ps=1.27 w=1 l=0.15
X7 a_391_297# B a_139_297# VPB sky130_fd_pr__pfet_01v8_hvt ad=0.135 pd=1.27 as=0.135 ps=1.27 w=1 l=0.15
X8 a_139_297# A VPWR VPB sky130_fd_pr__pfet_01v8_hvt ad=0.135 pd=1.27 as=0.135 ps=1.27 w=1 l=0.15
X9 VPWR A a_139_297# VPB sky130_fd_pr__pfet_01v8_hvt ad=0.135 pd=1.27 as=0.135 ps=1.27 w=1 l=0.15
X10 Y C a_391_297# VPB sky130_fd_pr__pfet_01v8_hvt ad=0.26 pd=2.52 as=0.135 ps=1.27 w=1 l=0.15
X11 a_391_297# C Y VPB sky130_fd_pr__pfet_01v8_hvt ad=0.135 pd=1.27 as=0.135 ps=1.27 w=1 l=0.15
C0 VPWR C 0.02985f
C1 Y B 0.03667f
C2 VPWR a_391_297# 0.03389f
C3 a_139_297# VPB 0.00767f
C4 VGND A 0.02755f
C5 a_139_297# B 0.04204f
C6 VGND C 0.02523f
C7 VGND a_391_297# 0.00687f
C8 VPWR VPB 0.12468f
C9 A a_391_297# 0
C10 VPWR B 0.02962f
C11 C a_391_297# 0.03645f
C12 VGND VPB 0.01632f
C13 A VPB 0.08738f
C14 a_139_297# Y 0.01343f
C15 VGND B 0.02468f
C16 C VPB 0.0899f
C17 A B 0.03922f
C18 VPB a_391_297# 0.0068f
C19 C B 0.03373f
C20 VPWR Y 0.0798f
C21 B a_391_297# 0.03979f
C22 VPWR a_139_297# 0.19439f
C23 VGND Y 0.15198f
C24 Y A 0.02134f
C25 B VPB 0.08464f
C26 C Y 0.11011f
C27 VGND a_139_297# 0.01092f
C28 Y a_391_297# 0.11214f
C29 a_139_297# A 0.06571f
C30 C a_139_297# 0.00113f
C31 VPWR VGND 0.05126f
C32 a_139_297# a_391_297# 0.06723f
C33 VPWR A 0.05433f
C34 Y VPB 0.02417f
C35 VGND VNB 0.66039f
C36 Y VNB 0.26591f
C37 VPWR VNB 0.55878f
C38 VPB VNB 0.95915f
C39 a_391_297# VNB 0.08872f
C40 a_139_297# VNB 0.09146f
.ends
