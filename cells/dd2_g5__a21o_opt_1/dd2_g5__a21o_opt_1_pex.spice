* NGSPICE file created from dd2_g5__a21o_opt_1.ext - technology: sky130A

.subckt dd2_g5__a21o_opt_1 A B C VGND VNB VPB VPWR Y
X0 Y.t0 a_147_301.t5 VPWR.t1 VPB.t1 sky130_fd_pr__pfet_01v8_hvt ad=0.26 pd=2.52 as=0.1642 ps=1.33 w=1 l=0.15
X1 a_147_301.t3 B.t0 a_147_47.t1 VNB.t2 sky130_fd_pr__nfet_01v8 ad=0.10725 pd=0.98 as=0.08775 ps=0.92 w=0.65 l=0.15
X2 a_147_47.t0 A.t0 VGND.t0 VNB.t0 sky130_fd_pr__nfet_01v8 ad=0.08775 pd=0.92 as=0.169 ps=1.82 w=0.65 l=0.15
X3 Y.t1 a_147_301.t4 VGND.t2 VNB.t3 sky130_fd_pr__nfet_01v8 ad=0.169 pd=1.82 as=0.10725 ps=0.98 w=0.65 l=0.15
X4 VPWR.t0 C.t1 a_65_301.t1 VPB.t2 sky130_fd_pr__pfet_01v8_hvt ad=0.1642 pd=1.33 as=0.1617 ps=1.31 w=0.98 l=0.15
X5 VGND.t1 C.t0 a_147_301.t1 VNB.t1 sky130_fd_pr__nfet_01v8 ad=0.10725 pd=0.98 as=0.10725 ps=0.98 w=0.65 l=0.15
X6 a_65_301.t2 B.t1 a_147_301.t2 VPB.t3 sky130_fd_pr__pfet_01v8_hvt ad=0.1617 pd=1.31 as=0.1323 ps=1.25 w=0.98 l=0.15
X7 a_147_301.t0 A.t1 a_65_301.t0 VPB.t0 sky130_fd_pr__pfet_01v8_hvt ad=0.1323 pd=1.25 as=0.2548 ps=2.48 w=0.98 l=0.15
R0 VGND.n2 VGND.n1 205.666
R1 VGND.n0 VGND.t0 149.762
R2 VGND.n1 VGND.t1 30.462
R3 VGND.n1 VGND.t2 30.462
R4 VGND.n2 VGND.n0 13.0657
R5 VGND.n4 VGND.n3 9.3005
R6 VGND VGND.n4 6.77697
R7 VGND.n4 VGND.n0 4.14168
R8 VGND.n0 VGND 3.10353
R9 VGND.n3 VGND.n2 0.327965
R10 VGND.n3 VGND 0.0239375
R11 Y.n0 Y.t0 389.846
R12 Y.n0 Y.t1 209.923
R13 Y.n1 Y 6.4005
R14 Y Y.n1 3.2005
R15 Y.n1 Y.n0 0.213833
R16 VPWR.n1 VPWR.n0 333.575
R17 VPWR.n0 VPWR.t0 33.1689
R18 VPWR.n0 VPWR.t1 31.6036
R19 VPWR VPWR.n1 14.3483
R20 VPWR.n1 VPWR 0.0801404
R21 C.n0 C.t1 244.75
R22 C.n0 C.t0 169.237
R23 C C.n0 155.103
R24 B.n0 B.t1 244.75
R25 B.n0 B.t0 169.237
R26 B B.n0 155.103
R27 A.n0 A.t1 244.75
R28 A.n0 A.t0 169.237
R29 A A.n0 155.103
R30 VPB VPB.t0 307.788
R31 VPB.t2 VPB.t1 284.113
R32 VPB.t3 VPB.t2 284.113
R33 VPB.t0 VPB.t3 248.599
R34 VNB VNB.t0 1480.91
R35 VNB.t1 VNB.t3 1366.99
R36 VNB.t2 VNB.t1 1366.99
R37 VNB.t0 VNB.t2 1196.12
R38 a_147_47.t0 a_147_47.t1 49.8467
R39 a_65_301.t0 a_65_301.n0 565.736
R40 a_65_301.n0 a_65_301.t1 33.1689
R41 a_65_301.n0 a_65_301.t2 33.1689
R42 a_147_301.n3 a_147_301.n2 682.167
R43 a_147_301.n2 a_147_301.n0 248.284
R44 a_147_301.n1 a_147_301.t5 241.536
R45 a_147_301.n1 a_147_301.t4 169.237
R46 a_147_301.n2 a_147_301.n1 152
R47 a_147_301.n0 a_147_301.t1 30.462
R48 a_147_301.n0 a_147_301.t3 30.462
R49 a_147_301.n3 a_147_301.t2 27.1383
R50 a_147_301.t0 a_147_301.n3 27.1383
C0 VGND C 0.01676f
C1 VPWR B 0.00971f
C2 VGND VPWR 0.03109f
C3 Y A 0
C4 C VPB 0.02842f
C5 A B 0.03981f
C6 VPWR VPB 0.09003f
C7 Y B 0
C8 VGND A 0.02809f
C9 VGND Y 0.02257f
C10 VGND B 0.02116f
C11 A VPB 0.03224f
C12 Y VPB 0.0164f
C13 VPB B 0.02703f
C14 VPWR C 0.01971f
C15 VGND VPB 0.0158f
C16 Y C 0.0014f
C17 VPWR A 0.00929f
C18 C B 0.03685f
C19 VPWR Y 0.03264f
C20 VGND VNB 0.40553f
C21 Y VNB 0.06766f
C22 VPWR VNB 0.40454f
C23 C VNB 0.07858f
C24 B VNB 0.0762f
C25 A VNB 0.11079f
C26 VPB VNB 0.65503f
C27 a_147_301.t2 VNB 0.04577f
C28 a_147_301.t1 VNB 0.0369f
C29 a_147_301.t3 VNB 0.03478f
C30 a_147_301.n0 VNB 0.03776f
C31 a_147_301.n1 VNB 0.04193f
C32 a_147_301.n2 VNB 0.13529f
C33 a_147_301.n3 VNB 0.04235f
C34 a_147_301.t0 VNB 0.04025f
C35 a_65_301.t1 VNB 0.04653f
C36 a_65_301.t2 VNB 0.04361f
C37 a_65_301.n0 VNB 0.07958f
C38 a_65_301.t0 VNB 0.1317f
C39 a_147_47.t1 VNB 0.02969f
C40 a_147_47.t0 VNB 0.02568f
C41 VPB.t1 VNB 0.09798f
C42 VPB.t2 VNB 0.0409f
C43 VPB.t3 VNB 0.03834f
C44 VPB.t0 VNB 0.04005f
C45 A.n0 VNB 0.04496f
C46 B.n0 VNB 0.05618f
C47 C.n0 VNB 0.06212f
C48 VPWR.t1 VNB 0.02692f
C49 VPWR.t0 VNB 0.04315f
C50 VPWR.n0 VNB 0.03557f
C51 VPWR.n1 VNB 0.18591f
C52 Y.t0 VNB 0.06965f
C53 Y.t1 VNB 0.04189f
C54 Y.n0 VNB 0.0511f
C55 Y.n1 VNB 0.00555f
C56 VGND.t0 VNB 0.03095f
C57 VGND.n0 VNB 0.03088f
C58 VGND.t2 VNB 0.02013f
C59 VGND.t1 VNB 0.02719f
C60 VGND.n1 VNB 0.01139f
C61 VGND.n2 VNB 0.07963f
C62 VGND.n3 VNB 0.07589f
C63 VGND.n4 VNB 0.00115f
.ends
