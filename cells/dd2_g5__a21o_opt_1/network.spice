* dd2_g5__a21o_opt_1: Y = (A & B) | C
* Generated by synthesize.py; stages in signal order:
*   n1 = !((A & B) | C)
*   Y = !(n1)
.subckt dd2_g5__a21o_opt_1 A B C VGND VNB VPB VPWR Y
XN1 n1 A n1_d1 VNB sky130_fd_pr__nfet_01v8 w=0.65 l=0.15
XN2 n1_d1 B VGND VNB sky130_fd_pr__nfet_01v8 w=0.65 l=0.15
XN3 n1 C VGND VNB sky130_fd_pr__nfet_01v8 w=0.65 l=0.15
XP1 n1_u1 A VPWR VPB sky130_fd_pr__pfet_01v8_hvt w=0.98 l=0.15
XP2 n1_u1 B VPWR VPB sky130_fd_pr__pfet_01v8_hvt w=0.98 l=0.15
XP3 n1 C n1_u1 VPB sky130_fd_pr__pfet_01v8_hvt w=0.98 l=0.15
XN4 Y n1 VGND VNB sky130_fd_pr__nfet_01v8 w=0.65 l=0.15
XP4 Y n1 VPWR VPB sky130_fd_pr__pfet_01v8_hvt w=1 l=0.15
.ends dd2_g5__a21o_opt_1
