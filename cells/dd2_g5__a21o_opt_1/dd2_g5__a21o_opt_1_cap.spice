* NGSPICE file created from dd2_g5__a21o_opt_1.ext - technology: sky130A

.subckt dd2_g5__a21o_opt_1 A B C VGND VNB VPB VPWR Y
X0 Y a_147_301# VPWR VPB sky130_fd_pr__pfet_01v8_hvt ad=0.26 pd=2.52 as=0.1642 ps=1.33 w=1 l=0.15
X1 a_147_301# B a_147_47# VNB sky130_fd_pr__nfet_01v8 ad=0.10725 pd=0.98 as=0.08775 ps=0.92 w=0.65 l=0.15
X2 a_147_47# A VGND VNB sky130_fd_pr__nfet_01v8 ad=0.08775 pd=0.92 as=0.169 ps=1.82 w=0.65 l=0.15
X3 Y a_147_301# VGND VNB sky130_fd_pr__nfet_01v8 ad=0.169 pd=1.82 as=0.10725 ps=0.98 w=0.65 l=0.15
X4 VPWR C a_65_301# VPB sky130_fd_pr__pfet_01v8_hvt ad=0.1642 pd=1.33 as=0.1617 ps=1.31 w=0.98 l=0.15
X5 VGND C a_147_301# VNB sky130_fd_pr__nfet_01v8 ad=0.10725 pd=0.98 as=0.10725 ps=0.98 w=0.65 l=0.15
X6 a_65_301# B a_147_301# VPB sky130_fd_pr__pfet_01v8_hvt ad=0.1617 pd=1.31 as=0.1323 ps=1.25 w=0.98 l=0.15
X7 a_147_301# A a_65_301# VPB sky130_fd_pr__pfet_01v8_hvt ad=0.1323 pd=1.25 as=0.2548 ps=2.48 w=0.98 l=0.15
C0 VGND A 0.02809f
C1 a_65_301# VPB 0.01414f
C2 a_147_301# B 0.02271f
C3 B A 0.03981f
C4 C Y 0.0014f
C5 VGND B 0.02116f
C6 a_147_301# a_147_47# 0.00472f
C7 VGND a_147_47# 0.01289f
C8 a_147_47# B 0
C9 C VPB 0.02842f
C10 a_147_301# Y 0.05707f
C11 A Y 0
C12 a_65_301# VPWR 0.10604f
C13 VGND Y 0.02257f
C14 B Y 0
C15 a_147_301# VPB 0.04348f
C16 A VPB 0.03224f
C17 VGND VPB 0.0158f
C18 C VPWR 0.01971f
C19 B VPB 0.02703f
C20 a_147_301# VPWR 0.0523f
C21 A VPWR 0.00929f
C22 VGND VPWR 0.03109f
C23 VPB Y 0.0164f
C24 B VPWR 0.00971f
C25 C a_65_301# 0.00511f
C26 a_147_47# VPWR 0.00122f
C27 VPWR Y 0.03264f
C28 a_147_301# a_65_301# 0.04898f
C29 A a_65_301# 0.02367f
C30 VGND a_65_301# 0.008f
C31 B a_65_301# 0.01395f
C32 VPB VPWR 0.09003f
C33 a_147_47# a_65_301# 0
C34 a_147_301# C 0.08161f
C35 VGND C 0.01676f
C36 C B 0.03685f
C37 a_65_301# Y 0.00102f
C38 a_147_301# A 0.00428f
C39 VGND a_147_301# 0.08002f
C40 VGND VNB 0.44652f
C41 Y VNB 0.13138f
C42 VPWR VNB 0.37089f
C43 VPB VNB 0.60476f
C44 a_147_47# VNB 0.07485f
C45 a_65_301# VNB 0.05679f
.ends
