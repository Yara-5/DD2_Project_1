* NGSPICE file created from dd2_g5__maj4_1.ext - technology: sky130A

.subckt dd2_g5__maj4_1 A B C D VGND VNB VPB VPWR Y
X0 a_237_47# C a_153_47# VNB sky130_fd_pr__nfet_01v8 ad=0.10725 pd=0.98 as=0.08775 ps=0.92 w=0.65 l=0.15
X1 a_237_47# C a_525_297# VPB sky130_fd_pr__pfet_01v8_hvt ad=0.26 pd=2.52 as=0.135 ps=1.27 w=1 l=0.15
X2 a_71_297# A a_237_47# VPB sky130_fd_pr__pfet_01v8_hvt ad=0.165 pd=1.33 as=0.165 ps=1.33 w=1 l=0.15
X3 a_525_297# D a_71_297# VPB sky130_fd_pr__pfet_01v8_hvt ad=0.135 pd=1.27 as=0.165 ps=1.33 w=1 l=0.15
X4 VGND D a_429_47# VNB sky130_fd_pr__nfet_01v8 ad=0.08775 pd=0.92 as=0.10725 ps=0.98 w=0.65 l=0.15
X5 a_429_47# A a_333_47# VNB sky130_fd_pr__nfet_01v8 ad=0.10725 pd=0.98 as=0.10725 ps=0.98 w=0.65 l=0.15
X6 a_237_47# B a_71_297# VPB sky130_fd_pr__pfet_01v8_hvt ad=0.165 pd=1.33 as=0.165 ps=1.33 w=1 l=0.15
X7 Y a_237_47# VPWR VPB sky130_fd_pr__pfet_01v8_hvt ad=0.26 pd=2.52 as=0.26 ps=2.52 w=1 l=0.15
X8 a_71_297# C VPWR VPB sky130_fd_pr__pfet_01v8_hvt ad=0.165 pd=1.33 as=0.135 ps=1.27 w=1 l=0.15
X9 a_429_47# C VGND VNB sky130_fd_pr__nfet_01v8 ad=0.169 pd=1.82 as=0.08775 ps=0.92 w=0.65 l=0.15
X10 VPWR D a_71_297# VPB sky130_fd_pr__pfet_01v8_hvt ad=0.135 pd=1.27 as=0.26 ps=2.52 w=1 l=0.15
X11 a_153_47# D VGND VNB sky130_fd_pr__nfet_01v8 ad=0.08775 pd=0.92 as=0.169 ps=1.82 w=0.65 l=0.15
X12 Y a_237_47# VGND VNB sky130_fd_pr__nfet_01v8 ad=0.169 pd=1.82 as=0.169 ps=1.82 w=0.65 l=0.15
X13 a_333_47# B a_237_47# VNB sky130_fd_pr__nfet_01v8 ad=0.10725 pd=0.98 as=0.10725 ps=0.98 w=0.65 l=0.15
C0 A VGND 0.01457f
C1 Y a_333_47# 0
C2 a_333_47# a_237_47# 0.00753f
C3 A VPWR 0.00703f
C4 C VPB 0.06846f
C5 A D 0.05056f
C6 a_333_47# VGND 0.0099f
C7 a_71_297# VPB 0.01855f
C8 a_429_47# VPB 0.00184f
C9 B VPB 0.02683f
C10 Y VPB 0.01499f
C11 C a_153_47# 0
C12 a_237_47# VPB 0.0758f
C13 a_71_297# a_153_47# 0
C14 a_333_47# D 0.00467f
C15 Y a_153_47# 0
C16 VGND VPB 0.01483f
C17 a_153_47# a_237_47# 0.00929f
C18 A a_333_47# 0
C19 VPWR VPB 0.13573f
C20 a_153_47# VGND 0.00681f
C21 D VPB 0.05912f
C22 a_71_297# C 0.0493f
C23 C a_525_297# 0.00404f
C24 C a_429_47# 0.02623f
C25 C B 0.05028f
C26 C Y 0.00171f
C27 a_71_297# a_525_297# 0.00389f
C28 A VPB 0.02683f
C29 a_153_47# D 0.00265f
C30 a_71_297# a_429_47# 0
C31 a_429_47# a_525_297# 0
C32 C a_237_47# 0.18602f
C33 a_71_297# B 0.02077f
C34 a_429_47# B 0.00127f
C35 Y a_429_47# 0
C36 a_71_297# a_237_47# 0.17008f
C37 Y B 0
C38 a_237_47# a_525_297# 0.01641f
C39 a_429_47# a_237_47# 0.01891f
C40 B a_237_47# 0.01584f
C41 C VGND 0.03561f
C42 Y a_237_47# 0.04673f
C43 C VPWR 0.04832f
C44 a_71_297# VGND 0
C45 a_429_47# VGND 0.07298f
C46 B VGND 0.01348f
C47 Y VGND 0.03528f
C48 a_71_297# VPWR 0.1589f
C49 VPWR a_525_297# 0.00863f
C50 C D 0.1923f
C51 a_429_47# VPWR 0
C52 a_237_47# VGND 0.12121f
C53 VPWR B 0.00702f
C54 Y VPWR 0.0319f
C55 a_71_297# D 0.03415f
C56 a_525_297# D 0
C57 VPWR a_237_47# 0.15883f
C58 a_429_47# D 0.03993f
C59 B D 0.01131f
C60 Y D 0
C61 C A 0.01156f
C62 a_237_47# D 0.13915f
C63 a_71_297# A 0.01264f
C64 VPWR VGND 0.01998f
C65 a_429_47# A 0.00299f
C66 A B 0.03636f
C67 Y A 0
C68 VGND D 0.09223f
C69 C a_333_47# 0
C70 A a_237_47# 0.02264f
C71 VPWR D 0.02446f
C72 a_71_297# a_333_47# 0
C73 a_429_47# a_333_47# 0.00284f
C74 a_333_47# B 0
C75 VGND VNB 0.56176f
C76 Y VNB 0.22862f
C77 VPWR VNB 0.59528f
C78 VPB VNB 0.95915f
C79 a_429_47# VNB 0.00712f
C80 a_153_47# VNB 0.07214f
C81 a_525_297# VNB 0.08455f
C82 a_71_297# VNB 0.17391f
.ends
