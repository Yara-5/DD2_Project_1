* NGSPICE file created from dd2_g5__maj4_1.ext - technology: sky130A

.subckt dd2_g5__maj4_1 A B C D VGND VNB VPB VPWR Y
X0 a_237_47# C a_153_47# VNB sky130_fd_pr__nfet_01v8 ad=0.10725 pd=0.98 as=0.08775 ps=0.92 w=0.65 l=0.15
X1 a_237_47# C a_525_297# VPB sky130_fd_pr__pfet_01v8_hvt ad=0.26 pd=2.52 as=0.135 ps=1.27 w=1 l=0.15
X2 a_71_297# A a_237_47# VPB sky130_fd_pr__pfet_01v8_hvt ad=0.165 pd=1.33 as=0.165 ps=1.33 w=1 l=0.15
X3 a_525_297# D a_71_297# VPB sky130_fd_pr__pfet_01v8_hvt ad=0.135 pd=1.27 as=0.165 ps=1.33 w=1 l=0.15
X4 VGND D a_429_47# VNB sky130_fd_pr__nfet_01v8 ad=0.08775 pd=0.92 as=0.10725 ps=0.98 w=0.65 l=0.15
X5 a_429_47# A a_333_47# VNB sky130_fd_pr__nfet_01v8 ad=0.10725 pd=0.98 as=0.10725 ps=0.98 w=0.65 l=0.15
X6 a_237_47# B a_71_297# VPB sky130_fd_pr__pfet_01v8_hvt ad=0.165 pd=1.33 as=0.165 ps=1.33 w=1 l=0.15
X7 Y a_237_47# VPWR VPB sky130_fd_pr__pfet_01v8_hvt ad=0.26 pd=2.52 as=0.26 ps=2.52 w=1 l=0.15
X8 a_71_297# C VPWR VPB sky130_fd_pr__pfet_01v8_hvt ad=0.165 pd=1.33 as=0.135 ps=1.27 w=1 l=0.15
X9 a_429_47# C VGND VNB sky130_fd_pr__nfet_01v8 ad=0.169 pd=1.82 as=0.08775 ps=0.92 w=0.65 l=0.15
X10 VPWR D a_71_297# VPB sky130_fd_pr__pfet_01v8_hvt ad=0.135 pd=1.27 as=0.26 ps=2.52 w=1 l=0.15
X11 a_153_47# D VGND VNB sky130_fd_pr__nfet_01v8 ad=0.08775 pd=0.92 as=0.169 ps=1.82 w=0.65 l=0.15
X12 Y a_237_47# VGND VNB sky130_fd_pr__nfet_01v8 ad=0.169 pd=1.82 as=0.169 ps=1.82 w=0.65 l=0.15
X13 a_333_47# B a_237_47# VNB sky130_fd_pr__nfet_01v8 ad=0.10725 pd=0.98 as=0.10725 ps=0.98 w=0.65 l=0.15
C0 Y VPWR 0.02047f
C1 a_71_297# D 0.06756f
C2 a_525_297# D 0.00185f
C3 VPWR a_237_47# 0.08314f
C4 a_429_47# D 0.02301f
C5 B D 0.00826f
C6 Y D 0
C7 C A 0.0138f
C8 a_237_47# D 0.08482f
C9 a_71_297# A 0.00738f
C10 VPWR VGND 0.02072f
C11 a_429_47# A 0.00243f
C12 A B 0.03636f
C13 VGND D 0.04425f
C14 C a_333_47# 0.0011f
C15 A a_237_47# 0.0283f
C16 VPWR D 0.06566f
C17 a_71_297# a_333_47# 0
C18 a_429_47# a_333_47# 0
C19 a_333_47# B 0
C20 A VGND 0.01268f
C21 a_333_47# a_237_47# 0.01173f
C22 A VPWR 0.00669f
C23 C VPB 0.0602f
C24 A D 0.05102f
C25 a_333_47# VGND 0.00784f
C26 a_71_297# VPB 0.01438f
C27 a_429_47# VPB 0.00158f
C28 B VPB 0.02683f
C29 Y VPB 0.01327f
C30 C a_153_47# 0
C31 a_237_47# VPB 0.06208f
C32 a_71_297# a_153_47# 0.00156f
C33 VGND VPB 0.01408f
C34 a_153_47# a_237_47# 0.00348f
C35 A a_333_47# 0
C36 VPWR VPB 0.14591f
C37 a_153_47# VGND 0.00955f
C38 D VPB 0.07572f
C39 a_71_297# C 0.03093f
C40 C a_525_297# 0.00275f
C41 C a_429_47# 0.02535f
C42 C B 0.05508f
C43 C Y 0
C44 a_71_297# a_525_297# 0.00197f
C45 A VPB 0.02683f
C46 a_153_47# D 0.00406f
C47 a_71_297# a_429_47# 0
C48 a_429_47# a_525_297# 0
C49 C a_237_47# 0.14809f
C50 a_71_297# B 0.01802f
C51 a_71_297# Y 0
C52 a_429_47# B 0
C53 Y a_429_47# 0.00251f
C54 a_71_297# a_237_47# 0.06405f
C55 a_237_47# a_525_297# 0.01222f
C56 a_429_47# a_237_47# 0.06292f
C57 B a_237_47# 0.02274f
C58 C VGND 0.04646f
C59 Y a_237_47# 0.0463f
C60 C VPWR 0.03799f
C61 a_71_297# VGND 0.00647f
C62 a_429_47# VGND 0.0591f
C63 B VGND 0.0106f
C64 Y VGND 0.02385f
C65 a_71_297# VPWR 0.13379f
C66 VPWR a_525_297# 0.00808f
C67 C D 0.19277f
C68 a_429_47# VPWR 0
C69 a_237_47# VGND 0.14808f
C70 VPWR B 0.00784f
C71 VGND VNB 0.55859f
C72 Y VNB 0.19378f
C73 VPWR VNB 0.58049f
C74 VPB VNB 0.95915f
C75 a_429_47# VNB 0.00654f
C76 a_153_47# VNB 0.0689f
C77 a_525_297# VNB 0.08869f
C78 a_71_297# VNB 0.16624f
.ends
