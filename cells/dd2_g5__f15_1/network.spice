* dd2_g5__f15_1: Y = !A & ((!C & !D) | !B)
* Generated by synthesize.py; stages in signal order:
*   Y = !(A | ((C | D) & B))
.subckt dd2_g5__f15_1 A B C D VGND VNB VPB VPWR Y
XN1 Y A VGND VNB sky130_fd_pr__nfet_01v8 w=0.65 l=0.15
XN2 Y C Y_d1 VNB sky130_fd_pr__nfet_01v8 w=0.65 l=0.15
XN3 Y D Y_d1 VNB sky130_fd_pr__nfet_01v8 w=0.65 l=0.15
XN4 Y_d1 B VGND VNB sky130_fd_pr__nfet_01v8 w=0.65 l=0.15
XP1 Y_u1 A VPWR VPB sky130_fd_pr__pfet_01v8_hvt w=1 l=0.15
XP2 Y_u2 C Y_u1 VPB sky130_fd_pr__pfet_01v8_hvt w=1 l=0.15
XP3 Y D Y_u2 VPB sky130_fd_pr__pfet_01v8_hvt w=1 l=0.15
XP4 Y B Y_u1 VPB sky130_fd_pr__pfet_01v8_hvt w=1 l=0.15
.ends dd2_g5__f15_1
