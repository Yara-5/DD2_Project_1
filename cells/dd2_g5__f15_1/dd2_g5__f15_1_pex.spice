* NGSPICE file created from dd2_g5__f15_1.ext - technology: sky130A

.subckt dd2_g5__f15_1 A B C D VGND VNB VPB VPWR Y
X0 VGND.t2 C.t0 a_201_47.t2 VNB.t3 sky130_fd_pr__nfet_01v8 ad=0.08775 pd=0.92 as=0.10725 ps=0.98 w=0.65 l=0.15
X1 a_201_47.t0 B.t0 Y.t1 VNB.t0 sky130_fd_pr__nfet_01v8 ad=0.10725 pd=0.98 as=0.10075 ps=0.96 w=0.65 l=0.15
X2 a_109_297.t2 D.t1 a_297_297.t0 VPB.t2 sky130_fd_pr__pfet_01v8_hvt ad=0.26 pd=2.52 as=0.135 ps=1.27 w=1 l=0.15
X3 Y.t0 B.t1 a_109_297.t0 VPB.t0 sky130_fd_pr__pfet_01v8_hvt ad=0.165 pd=1.33 as=0.155 ps=1.31 w=1 l=0.15
X4 a_201_47.t1 D.t0 VGND.t0 VNB.t2 sky130_fd_pr__nfet_01v8 ad=0.169 pd=1.82 as=0.08775 ps=0.92 w=0.65 l=0.15
X5 a_297_297.t1 C.t1 Y.t3 VPB.t3 sky130_fd_pr__pfet_01v8_hvt ad=0.135 pd=1.27 as=0.165 ps=1.33 w=1 l=0.15
X6 a_109_297.t1 A.t1 VPWR.t0 VPB.t1 sky130_fd_pr__pfet_01v8_hvt ad=0.155 pd=1.31 as=0.26 ps=2.52 w=1 l=0.15
X7 Y.t2 A.t0 VGND.t1 VNB.t1 sky130_fd_pr__nfet_01v8 ad=0.10075 pd=0.96 as=0.169 ps=1.82 w=0.65 l=0.15
R0 VGND.n2 VGND.t1 282.817
R1 VGND.n1 VGND.n0 205.728
R2 VGND.n0 VGND.t0 24.9236
R3 VGND.n0 VGND.t2 24.9236
R4 VGND.n2 VGND.n1 6.8485
R5 VGND VGND.n2 3.10353
R6 VGND.n1 VGND 0.138322
R7 Y.n2 Y.n0 686.662
R8 Y.n2 Y.n1 185
R9 Y.n0 Y.t3 32.5055
R10 Y.n0 Y.t0 32.5055
R11 Y.n1 Y.t1 28.6159
R12 Y.n1 Y.t2 28.6159
R13 Y.n3 Y 6.4005
R14 Y Y.n3 3.42907
R15 Y.n3 Y.n2 0.229071
R16 VPWR VPWR.t0 347.193
R17 VPWR.n0 VPWR 7.24445
R18 VPWR VPWR.n0 7.18394
R19 VPWR.n0 VPWR 2.1311
R20 D.n0 D.t1 241.536
R21 D.n0 D.t0 169.237
R22 D D.n0 155.103
R23 C.n0 C.t1 241.536
R24 C.n0 C.t0 169.237
R25 C C.n0 155.103
R26 B.n0 B.t1 241.536
R27 B.n0 B.t0 169.237
R28 B B.n0 155.103
R29 A.n0 A.t1 230.155
R30 A.n0 A.t0 157.856
R31 A A.n0 155.103
R32 VPB.t0 VPB.t3 284.113
R33 VPB.t1 VPB.t0 272.274
R34 VPB.t3 VPB.t2 248.599
R35 VPB VPB.t1 195.327
R36 VNB.t0 VNB.t3 1366.99
R37 VNB.t1 VNB.t0 1310.03
R38 VNB.t3 VNB.t2 1196.12
R39 VNB VNB.t1 939.807
R40 a_201_47.n0 a_201_47.t1 455.611
R41 a_201_47.n0 a_201_47.t2 30.462
R42 a_201_47.t0 a_201_47.n0 30.462
R43 a_297_297.t0 a_297_297.t1 53.1905
R44 a_109_297.n0 a_109_297.t2 600.578
R45 a_109_297.t0 a_109_297.n0 30.5355
R46 a_109_297.n0 a_109_297.t1 30.5355
C0 Y C 0.00409f
C1 VGND Y 0.02825f
C2 D C 0.03922f
C3 D VGND 0.01502f
C4 C VPB 0.02591f
C5 VGND VPB 0.00733f
C6 Y A 0.03168f
C7 VPB A 0.03803f
C8 VPWR C 0.00935f
C9 VPWR VGND 0.02726f
C10 C B 0.03636f
C11 VGND B 0.01934f
C12 VPWR A 0.02781f
C13 B A 0.02424f
C14 VGND C 0.01595f
C15 VGND A 0.02687f
C16 D Y 0.00178f
C17 Y VPB 0.01215f
C18 D VPB 0.02928f
C19 VPWR Y 0.01219f
C20 VPWR D 0.00876f
C21 VPWR VPB 0.06143f
C22 Y B 0.04042f
C23 B VPB 0.02655f
C24 VPWR B 0.00978f
C25 VGND VNB 0.3956f
C26 Y VNB 0.04739f
C27 VPWR VNB 0.52303f
C28 D VNB 0.11176f
C29 C VNB 0.07548f
C30 B VNB 0.07686f
C31 A VNB 0.12937f
C32 VPB VNB 0.55595f
C33 a_109_297.t1 VNB 0.03988f
C34 a_109_297.t2 VNB 0.16227f
C35 a_109_297.n0 VNB 0.09943f
C36 a_109_297.t0 VNB 0.0458f
C37 a_297_297.t1 VNB 0.04037f
C38 a_297_297.t0 VNB 0.0355f
C39 a_201_47.t2 VNB 0.03105f
C40 a_201_47.t1 VNB 0.07474f
C41 a_201_47.n0 VNB 0.05146f
C42 a_201_47.t0 VNB 0.03176f
C43 VPB.t2 VNB 0.06993f
C44 VPB.t3 VNB 0.03617f
C45 VPB.t0 VNB 0.03778f
C46 VPB.t1 VNB 0.03175f
C47 A.n0 VNB 0.06217f
C48 B.n0 VNB 0.05609f
C49 C.n0 VNB 0.05412f
C50 D.n0 VNB 0.04431f
C51 VPWR.t0 VNB 0.06199f
C52 VPWR.n0 VNB 0.00388f
C53 Y.t3 VNB 0.04516f
C54 Y.t0 VNB 0.04614f
C55 Y.n0 VNB 0.04199f
C56 Y.t1 VNB 0.0313f
C57 Y.t2 VNB 0.02699f
C58 Y.n1 VNB 0.02232f
C59 Y.n2 VNB 0.06446f
C60 Y.n3 VNB 0.00691f
C61 VGND.t0 VNB 0.02033f
C62 VGND.t2 VNB 0.02385f
C63 VGND.n0 VNB 0.01039f
C64 VGND.n1 VNB 0.07657f
C65 VGND.t1 VNB 0.03152f
C66 VGND.n2 VNB 0.0239f
.ends
