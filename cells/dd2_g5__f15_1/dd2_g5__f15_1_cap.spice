* NGSPICE file created from dd2_g5__f15_1.ext - technology: sky130A

.subckt dd2_g5__f15_1 A B C D VGND VNB VPB VPWR Y
X0 VGND C a_201_47# VNB sky130_fd_pr__nfet_01v8 ad=0.08775 pd=0.92 as=0.10725 ps=0.98 w=0.65 l=0.15
X1 a_201_47# B Y VNB sky130_fd_pr__nfet_01v8 ad=0.10725 pd=0.98 as=0.10075 ps=0.96 w=0.65 l=0.15
X2 a_109_297# D a_297_297# VPB sky130_fd_pr__pfet_01v8_hvt ad=0.26 pd=2.52 as=0.135 ps=1.27 w=1 l=0.15
X3 Y B a_109_297# VPB sky130_fd_pr__pfet_01v8_hvt ad=0.165 pd=1.33 as=0.155 ps=1.31 w=1 l=0.15
X4 a_201_47# D VGND VNB sky130_fd_pr__nfet_01v8 ad=0.169 pd=1.82 as=0.08775 ps=0.92 w=0.65 l=0.15
X5 a_297_297# C Y VPB sky130_fd_pr__pfet_01v8_hvt ad=0.135 pd=1.27 as=0.165 ps=1.33 w=1 l=0.15
X6 a_109_297# A VPWR VPB sky130_fd_pr__pfet_01v8_hvt ad=0.155 pd=1.31 as=0.26 ps=2.52 w=1 l=0.15
X7 Y A VGND VNB sky130_fd_pr__nfet_01v8 ad=0.10075 pd=0.96 as=0.169 ps=1.82 w=0.65 l=0.15
C0 a_297_297# VPWR 0.00445f
C1 D VPWR 0.00921f
C2 VGND B 0.01936f
C3 A B 0.02424f
C4 B a_109_297# 0.00839f
C5 VPB VGND 0.00792f
C6 B Y 0.04055f
C7 VPB A 0.03803f
C8 C B 0.03636f
C9 a_201_47# B 0.00299f
C10 VPB a_109_297# 0.0114f
C11 VPB Y 0.01383f
C12 C VPB 0.02591f
C13 VPB a_201_47# 0.00184f
C14 VPWR B 0.00986f
C15 VGND A 0.02689f
C16 VGND a_109_297# 0.00524f
C17 VPB VPWR 0.05903f
C18 A a_109_297# 0.002f
C19 VGND Y 0.02825f
C20 A Y 0.03181f
C21 C VGND 0.01595f
C22 VGND a_201_47# 0.06377f
C23 a_109_297# Y 0.03319f
C24 C a_109_297# 0.01187f
C25 a_201_47# a_109_297# 0.00617f
C26 C Y 0.00409f
C27 a_201_47# Y 0.01596f
C28 C a_201_47# 0.01814f
C29 D VPB 0.02928f
C30 VGND VPWR 0.02741f
C31 VPWR A 0.02436f
C32 VPWR a_109_297# 0.11093f
C33 VPWR Y 0.01219f
C34 C VPWR 0.00935f
C35 a_201_47# VPWR 0.00279f
C36 VGND a_297_297# 0.00185f
C37 D VGND 0.01519f
C38 a_297_297# a_109_297# 0.00841f
C39 D a_109_297# 0.01318f
C40 a_297_297# Y 0.00242f
C41 D Y 0.00198f
C42 C a_297_297# 0
C43 a_297_297# a_201_47# 0.0027f
C44 C D 0.03922f
C45 D a_201_47# 0.01928f
C46 VPB B 0.02655f
C47 VGND VNB 0.34422f
C48 Y VNB 0.07994f
C49 VPWR VNB 0.31571f
C50 VPB VNB 0.51617f
C51 a_201_47# VNB 0.07465f
C52 a_297_297# VNB 0.04767f
C53 a_109_297# VNB 0.11228f
.ends
