* NGSPICE file created from dd2_g5__f15_1.ext - technology: sky130A

.subckt dd2_g5__f15_1 A B C D VGND VNB VPB VPWR Y
X0 VGND C a_201_47# VNB sky130_fd_pr__nfet_01v8 ad=0.08775 pd=0.92 as=0.10725 ps=0.98 w=0.65 l=0.15
X1 a_201_47# B Y VNB sky130_fd_pr__nfet_01v8 ad=0.10725 pd=0.98 as=0.10075 ps=0.96 w=0.65 l=0.15
X2 a_109_297# D a_297_297# VPB sky130_fd_pr__pfet_01v8_hvt ad=0.26 pd=2.52 as=0.135 ps=1.27 w=1 l=0.15
X3 Y B a_109_297# VPB sky130_fd_pr__pfet_01v8_hvt ad=0.165 pd=1.33 as=0.155 ps=1.31 w=1 l=0.15
X4 a_201_47# D VGND VNB sky130_fd_pr__nfet_01v8 ad=0.169 pd=1.82 as=0.08775 ps=0.92 w=0.65 l=0.15
X5 a_297_297# C Y VPB sky130_fd_pr__pfet_01v8_hvt ad=0.135 pd=1.27 as=0.165 ps=1.33 w=1 l=0.15
X6 a_109_297# A VPWR VPB sky130_fd_pr__pfet_01v8_hvt ad=0.155 pd=1.31 as=0.26 ps=2.52 w=1 l=0.15
X7 Y A VGND VNB sky130_fd_pr__nfet_01v8 ad=0.10075 pd=0.96 as=0.169 ps=1.82 w=0.65 l=0.15
C0 VPWR B 0.00978f
C1 VGND A 0.02687f
C2 VGND a_109_297# 0.00487f
C3 VPB VPWR 0.06143f
C4 A a_109_297# 0.00518f
C5 VGND Y 0.02825f
C6 A Y 0.03168f
C7 C VGND 0.01595f
C8 VGND a_201_47# 0.06377f
C9 a_109_297# Y 0.04487f
C10 C a_109_297# 0.01701f
C11 a_201_47# a_109_297# 0.00605f
C12 C Y 0.00409f
C13 a_201_47# Y 0.01596f
C14 C a_201_47# 0.01814f
C15 D VPB 0.02928f
C16 VGND VPWR 0.02726f
C17 VPWR A 0.02781f
C18 VPWR a_109_297# 0.13399f
C19 VPWR Y 0.01219f
C20 C VPWR 0.00935f
C21 a_201_47# VPWR 0.00279f
C22 VGND a_297_297# 0.00185f
C23 D VGND 0.01502f
C24 a_297_297# a_109_297# 0.01538f
C25 D a_109_297# 0.02274f
C26 a_297_297# Y 0.00242f
C27 D Y 0.00178f
C28 C a_297_297# 0
C29 a_297_297# a_201_47# 0.0027f
C30 C D 0.03922f
C31 D a_201_47# 0.01928f
C32 VPB B 0.02655f
C33 a_297_297# VPWR 0.00445f
C34 D VPWR 0.00876f
C35 VGND B 0.01934f
C36 A B 0.02424f
C37 B a_109_297# 0.01259f
C38 VPB VGND 0.00733f
C39 B Y 0.04042f
C40 VPB A 0.03803f
C41 C B 0.03636f
C42 a_201_47# B 0.00299f
C43 VPB a_109_297# 0.01289f
C44 VPB Y 0.01215f
C45 C VPB 0.02591f
C46 VPB a_201_47# 0.00184f
C47 VGND VNB 0.34421f
C48 Y VNB 0.07456f
C49 VPWR VNB 0.32534f
C50 VPB VNB 0.51617f
C51 a_201_47# VNB 0.07465f
C52 a_297_297# VNB 0.04767f
C53 a_109_297# VNB 0.13708f
.ends
