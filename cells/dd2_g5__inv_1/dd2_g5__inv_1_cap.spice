* NGSPICE file created from dd2_g5__inv_1.ext - technology: sky130A

.subckt dd2_g5__inv_1 A VGND VNB VPB VPWR Y
X0 Y A VPWR VPB sky130_fd_pr__pfet_01v8_hvt ad=0.26 pd=2.52 as=0.26 ps=2.52 w=1 l=0.15
X1 Y A VGND VNB sky130_fd_pr__nfet_01v8 ad=0.169 pd=1.82 as=0.169 ps=1.82 w=0.65 l=0.15
C0 VPB A 0.03662f
C1 VGND VPWR 0.02259f
C2 A Y 0.03512f
C3 VPB VPWR 0.06812f
C4 VGND VPB 0.01348f
C5 VPWR Y 0.06809f
C6 VGND Y 0.03524f
C7 A VPWR 0.02369f
C8 VGND A 0.02541f
C9 VPB Y 0.01817f
C10 VGND VNB 0.25023f
C11 Y VNB 0.14558f
C12 VPWR VNB 0.2686f
C13 VPB VNB 0.33898f
.ends
