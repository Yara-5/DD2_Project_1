* NGSPICE file created from dd2_g5__inv_1.ext - technology: sky130A

.subckt dd2_g5__inv_1 A VGND VNB VPB VPWR Y
X0 Y.t1 A.t1 VPWR.t0 VPB.t0 sky130_fd_pr__pfet_01v8_hvt ad=0.26 pd=2.52 as=0.26 ps=2.52 w=1 l=0.15
X1 Y.t0 A.t0 VGND.t0 VNB.t0 sky130_fd_pr__nfet_01v8 ad=0.169 pd=1.82 as=0.169 ps=1.82 w=0.65 l=0.15
R0 VGND.n0 VGND.t0 285.481
R1 VGND VGND.n0 8.99118
R2 VGND.n0 VGND 3.89393
R3 Y.n0 Y.t1 895.778
R4 Y.n0 Y.t0 209.923
R5 Y.n1 Y 6.4005
R6 Y Y.n1 3.2005
R7 Y.n1 Y.n0 0.213833
R8 VPWR.n0 VPWR.t0 884.784
R9 VPWR VPWR.n0 10.1613
R10 VPWR.n0 VPWR 4.2688
R11 A.n0 A.t1 241.536
R12 A.n0 A.t0 169.237
R13 A A.n0 155.103
R14 VPB VPB.t0 348.154
R15 VNB VNB.t0 1600
C0 A VGND 0.0214f
C1 VGND VPB 0.01454f
C2 A VPWR 0.02077f
C3 VPWR VPB 0.06396f
C4 VGND Y 0.02402f
C5 Y VPWR 0.02047f
C6 A VPB 0.03665f
C7 A Y 0.02628f
C8 Y VPB 0.0158f
C9 VGND VPWR 0.02291f
C10 VGND VNB 0.29233f
C11 Y VNB 0.08615f
C12 VPWR VNB 0.27806f
C13 A VNB 0.13287f
C14 VPB VNB 0.38813f
C15 VPB.t0 VNB 0.08179f
C16 A.n0 VNB 0.03422f
C17 VPWR.t0 VNB 0.04161f
C18 VPWR.n0 VNB 0.01972f
C19 Y.t1 VNB 0.0474f
C20 Y.t0 VNB 0.03137f
C21 Y.n0 VNB 0.03362f
C22 Y.n1 VNB 0.00396f
C23 VGND.t0 VNB 0.02329f
C24 VGND.n0 VNB 0.01849f
.ends
