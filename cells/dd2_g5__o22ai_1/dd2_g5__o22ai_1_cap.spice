* NGSPICE file created from dd2_g5__o22ai_1.ext - technology: sky130A

.subckt dd2_g5__o22ai_1 A B C D VGND VNB VPB VPWR Y
X0 a_407_297# C Y VPB sky130_fd_pr__pfet_01v8_hvt ad=0.265 pd=1.53 as=0.275 ps=1.55 w=1 l=0.15
X1 VGND A a_49_47# VNB sky130_fd_pr__nfet_01v8 ad=0.17225 pd=1.18 as=0.169 ps=1.82 w=0.65 l=0.15
X2 VPWR D a_407_297# VPB sky130_fd_pr__pfet_01v8_hvt ad=0.26 pd=2.52 as=0.265 ps=1.53 w=1 l=0.15
X3 a_49_47# B VGND VNB sky130_fd_pr__nfet_01v8 ad=0.17875 pd=1.2 as=0.17225 ps=1.18 w=0.65 l=0.15
X4 a_49_47# D Y VNB sky130_fd_pr__nfet_01v8 ad=0.169 pd=1.82 as=0.17225 ps=1.18 w=0.65 l=0.15
X5 a_131_297# A VPWR VPB sky130_fd_pr__pfet_01v8_hvt ad=0.265 pd=1.53 as=0.26 ps=2.52 w=1 l=0.15
X6 Y B a_131_297# VPB sky130_fd_pr__pfet_01v8_hvt ad=0.275 pd=1.55 as=0.265 ps=1.53 w=1 l=0.15
X7 Y C a_49_47# VNB sky130_fd_pr__nfet_01v8 ad=0.17225 pd=1.18 as=0.17875 ps=1.2 w=0.65 l=0.15
C0 a_407_297# VPWR 0.01569f
C1 D VPWR 0.0165f
C2 VGND B 0.01479f
C3 A B 0.01429f
C4 B a_131_297# 0
C5 VPB VGND 0.01238f
C6 B Y 0
C7 VPB A 0.03367f
C8 C B 0.02147f
C9 a_49_47# B 0.06115f
C10 VPB Y 0.0083f
C11 C VPB 0.03225f
C12 D a_407_297# 0
C13 VPB a_49_47# 0.02906f
C14 VPWR B 0.01147f
C15 VGND A 0.01562f
C16 VGND a_131_297# 0.00356f
C17 VPB VPWR 0.1078f
C18 VGND Y 0.03011f
C19 C VGND 0.01724f
C20 VGND a_49_47# 0.11357f
C21 a_49_47# A 0.04105f
C22 a_131_297# Y 0
C23 a_49_47# a_131_297# 0.02146f
C24 C Y 0.0391f
C25 a_49_47# Y 0.10552f
C26 C a_49_47# 0.0144f
C27 D VPB 0.03344f
C28 VGND VPWR 0.03548f
C29 VPWR A 0.02089f
C30 VPWR a_131_297# 0.0231f
C31 VPWR Y 0.02158f
C32 C VPWR 0.01268f
C33 a_49_47# VPWR 0.09748f
C34 VGND a_407_297# 0.00325f
C35 D VGND 0.01682f
C36 a_407_297# Y 0.00971f
C37 D Y 0.02345f
C38 a_407_297# a_49_47# 0.02295f
C39 C D 0.01429f
C40 D a_49_47# 0.04249f
C41 VPB B 0.03225f
C42 VGND VNB 0.48671f
C43 Y VNB 0.04452f
C44 VPWR VNB 0.38644f
C45 VPB VNB 0.69336f
C46 a_49_47# VNB 0.2062f
C47 a_407_297# VNB 0.07774f
.ends
