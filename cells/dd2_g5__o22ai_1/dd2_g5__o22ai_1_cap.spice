* NGSPICE file created from dd2_g5__o22ai_1.ext - technology: sky130A

.subckt dd2_g5__o22ai_1 A B C D VGND VNB VPB VPWR Y
X0 Y B a_109_297# VPB sky130_fd_pr__pfet_01v8_hvt ad=0.165 pd=1.33 as=0.135 ps=1.27 w=1 l=0.15
X1 a_289_297# C Y VPB sky130_fd_pr__pfet_01v8_hvt ad=0.155 pd=1.31 as=0.165 ps=1.33 w=1 l=0.15
X2 a_27_47# B VGND VNB sky130_fd_pr__nfet_01v8 ad=0.10725 pd=0.98 as=0.08775 ps=0.92 w=0.65 l=0.15
X3 VPWR D a_289_297# VPB sky130_fd_pr__pfet_01v8_hvt ad=0.26 pd=2.52 as=0.155 ps=1.31 w=1 l=0.15
X4 Y C a_27_47# VNB sky130_fd_pr__nfet_01v8 ad=0.10075 pd=0.96 as=0.10725 ps=0.98 w=0.65 l=0.15
X5 a_27_47# D Y VNB sky130_fd_pr__nfet_01v8 ad=0.169 pd=1.82 as=0.10075 ps=0.96 w=0.65 l=0.15
X6 a_109_297# A VPWR VPB sky130_fd_pr__pfet_01v8_hvt ad=0.135 pd=1.27 as=0.26 ps=2.52 w=1 l=0.15
X7 VGND A a_27_47# VNB sky130_fd_pr__nfet_01v8 ad=0.08775 pd=0.92 as=0.169 ps=1.82 w=0.65 l=0.15
C0 VPB Y 0.01107f
C1 C VPB 0.02655f
C2 VPB a_27_47# 0.0039f
C3 VPWR B 0.0207f
C4 VGND A 0.01534f
C5 VGND a_109_297# 0.00213f
C6 VPB VPWR 0.08655f
C7 VGND Y 0.0099f
C8 A Y 0.00502f
C9 C VGND 0.01031f
C10 VGND a_27_47# 0.12561f
C11 a_27_47# A 0.01781f
C12 a_109_297# Y 0.00688f
C13 a_27_47# a_109_297# 0.00317f
C14 C Y 0.04807f
C15 a_27_47# Y 0.0361f
C16 C a_27_47# 0.01486f
C17 D VPB 0.03803f
C18 VGND VPWR 0.02562f
C19 VPWR A 0.02924f
C20 VPWR a_109_297# 0.0176f
C21 VPWR Y 0.06563f
C22 C VPWR 0.01639f
C23 a_27_47# VPWR 0.01236f
C24 VGND a_289_297# 0.0019f
C25 D VGND 0.01079f
C26 a_289_297# Y 0.01587f
C27 D Y 0.0335f
C28 C a_289_297# 0
C29 C D 0.02424f
C30 D a_27_47# 0.01669f
C31 VPB B 0.02595f
C32 a_289_297# VPWR 0.01579f
C33 D VPWR 0.0284f
C34 VGND B 0.01548f
C35 A B 0.03922f
C36 B a_109_297# 0
C37 VPB VGND 0.00636f
C38 B Y 0.01098f
C39 VPB A 0.02938f
C40 C B 0.03636f
C41 a_27_47# B 0.01869f
C42 VGND VNB 0.30343f
C43 Y VNB 0.09541f
C44 VPWR VNB 0.40618f
C45 VPB VNB 0.51617f
C46 a_27_47# VNB 0.03387f
C47 a_289_297# VNB 0.08433f
C48 a_109_297# VNB 0.07537f
.ends
