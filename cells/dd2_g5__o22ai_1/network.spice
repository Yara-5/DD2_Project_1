* dd2_g5__o22ai_1: Y = (!A & !B) | (!C & !D)
* Generated by synthesize.py; stages in signal order:
*   Y = !((A | B) & (C | D))
.subckt dd2_g5__o22ai_1 A B C D VGND VNB VPB VPWR Y
XN1 Y A Y_d1 VNB sky130_fd_pr__nfet_01v8 w=0.65 l=0.15
XN2 Y B Y_d1 VNB sky130_fd_pr__nfet_01v8 w=0.65 l=0.15
XN3 Y_d1 C VGND VNB sky130_fd_pr__nfet_01v8 w=0.65 l=0.15
XN4 Y_d1 D VGND VNB sky130_fd_pr__nfet_01v8 w=0.65 l=0.15
XP1 Y_u1 A VPWR VPB sky130_fd_pr__pfet_01v8_hvt w=1 l=0.15
XP2 Y B Y_u1 VPB sky130_fd_pr__pfet_01v8_hvt w=1 l=0.15
XP3 Y_u2 C VPWR VPB sky130_fd_pr__pfet_01v8_hvt w=1 l=0.15
XP4 Y D Y_u2 VPB sky130_fd_pr__pfet_01v8_hvt w=1 l=0.15
.ends dd2_g5__o22ai_1
