* NGSPICE file created from dd2_g5__o22ai_1.ext - technology: sky130A

.subckt dd2_g5__o22ai_1 A B C D VGND VNB VPB VPWR Y
X0 Y.t1 B.t1 a_109_297.t0 VPB.t0 sky130_fd_pr__pfet_01v8_hvt ad=0.165 pd=1.33 as=0.135 ps=1.27 w=1 l=0.15
X1 a_289_297.t1 C.t1 Y.t3 VPB.t3 sky130_fd_pr__pfet_01v8_hvt ad=0.155 pd=1.31 as=0.165 ps=1.33 w=1 l=0.15
X2 a_27_47.t0 B.t0 VGND.t1 VNB.t0 sky130_fd_pr__nfet_01v8 ad=0.10725 pd=0.98 as=0.08775 ps=0.92 w=0.65 l=0.15
X3 VPWR.t0 D.t1 a_289_297.t0 VPB.t2 sky130_fd_pr__pfet_01v8_hvt ad=0.26 pd=2.52 as=0.155 ps=1.31 w=1 l=0.15
X4 Y.t2 C.t0 a_27_47.t3 VNB.t3 sky130_fd_pr__nfet_01v8 ad=0.10075 pd=0.96 as=0.10725 ps=0.98 w=0.65 l=0.15
X5 a_27_47.t2 D.t0 Y.t0 VNB.t2 sky130_fd_pr__nfet_01v8 ad=0.169 pd=1.82 as=0.10075 ps=0.96 w=0.65 l=0.15
X6 a_109_297.t1 A.t1 VPWR.t1 VPB.t1 sky130_fd_pr__pfet_01v8_hvt ad=0.135 pd=1.27 as=0.26 ps=2.52 w=1 l=0.15
X7 VGND.t0 A.t0 a_27_47.t1 VNB.t1 sky130_fd_pr__nfet_01v8 ad=0.08775 pd=0.92 as=0.169 ps=1.82 w=0.65 l=0.15
R0 VGND.n1 VGND.n0 203.838
R1 VGND.n0 VGND.t1 24.9236
R2 VGND.n0 VGND.t0 24.9236
R3 VGND VGND.n1 12.0267
R4 VGND.n1 VGND 1.80019
R5 Y.n3 Y.n0 289.548
R6 Y.n2 Y.n1 185
R7 Y.n0 Y.t3 32.5055
R8 Y.n0 Y.t1 32.5055
R9 Y.n1 Y.t0 28.6159
R10 Y.n1 Y.t2 28.6159
R11 Y.n2 Y 6.02403
R12 Y Y.n3 5.68939
R13 Y.n3 Y.n2 1.88285
R14 VPWR.n1 VPWR.t0 356.75
R15 VPWR VPWR.t1 257.096
R16 VPWR.n1 VPWR.n0 39.9127
R17 VPWR.n3 VPWR.n2 9.3005
R18 VPWR VPWR.n3 6.77697
R19 VPWR.n3 VPWR.n0 2.25932
R20 VPWR.n0 VPWR 0.376971
R21 VPWR.n2 VPWR.n1 0.212172
R22 VPWR.n2 VPWR 0.0239375
R23 D.n0 D.t1 230.155
R24 D.n0 D.t0 157.856
R25 D D.n0 155.103
R26 C.n0 C.t1 241.536
R27 C.n0 C.t0 169.237
R28 C C.n0 155.103
R29 B.n0 B.t1 241.536
R30 B.n0 B.t0 169.237
R31 B B.n0 155.103
R32 A.n0 A.t1 241.536
R33 A.n0 A.t0 169.237
R34 A A.n0 155.103
R35 VPB.t0 VPB.t3 284.113
R36 VPB.t3 VPB.t2 272.274
R37 VPB.t1 VPB.t0 248.599
R38 VPB VPB.t1 195.327
R39 VNB.t0 VNB.t3 1366.99
R40 VNB.t3 VNB.t2 1310.03
R41 VNB.t1 VNB.t0 1196.12
R42 VNB VNB.t1 939.807
R43 a_27_47.n0 a_27_47.t2 336.861
R44 a_27_47.n0 a_27_47.t1 322.051
R45 a_27_47.n1 a_27_47.n0 185
R46 a_27_47.n1 a_27_47.t3 30.462
R47 a_27_47.t0 a_27_47.n1 30.462
R48 a_289_297.t0 a_289_297.t1 61.0705
R49 a_109_297.t0 a_109_297.t1 53.1905
C0 VGND VPWR 0.02562f
C1 D VPB 0.03803f
C2 A B 0.03922f
C3 VGND B 0.01548f
C4 VPWR D 0.0284f
C5 VGND C 0.01031f
C6 VPWR VPB 0.08655f
C7 C D 0.02424f
C8 A Y 0.00502f
C9 B VPB 0.02595f
C10 VGND Y 0.0099f
C11 VPWR B 0.0207f
C12 C VPB 0.02655f
C13 D Y 0.0335f
C14 VPWR C 0.01639f
C15 C B 0.03636f
C16 VPB Y 0.01107f
C17 VGND A 0.01534f
C18 VPWR Y 0.06563f
C19 VGND D 0.01079f
C20 B Y 0.01098f
C21 A VPB 0.02938f
C22 C Y 0.04807f
C23 VGND VPB 0.00636f
C24 VPWR A 0.02924f
C25 VGND VNB 0.46877f
C26 Y VNB 0.0469f
C27 VPWR VNB 0.34455f
C28 D VNB 0.12913f
C29 C VNB 0.07731f
C30 B VNB 0.07564f
C31 A VNB 0.11175f
C32 VPB VNB 0.55824f
C33 a_109_297.t1 VNB 0.03699f
C34 a_109_297.t0 VNB 0.0421f
C35 a_289_297.t1 VNB 0.04537f
C36 a_289_297.t0 VNB 0.03841f
C37 a_27_47.t3 VNB 0.03438f
C38 a_27_47.t1 VNB 0.06042f
C39 a_27_47.t2 VNB 0.06155f
C40 a_27_47.n0 VNB 0.1039f
C41 a_27_47.n1 VNB 0.02742f
C42 a_27_47.t0 VNB 0.0333f
C43 VPB.t2 VNB 0.07565f
C44 VPB.t3 VNB 0.03995f
C45 VPB.t0 VNB 0.03825f
C46 VPB.t1 VNB 0.03188f
C47 A.n0 VNB 0.04428f
C48 B.n0 VNB 0.05456f
C49 C.n0 VNB 0.05755f
C50 D.n0 VNB 0.06129f
C51 VPWR.t1 VNB 0.05777f
C52 VPWR.n0 VNB 0.0077f
C53 VPWR.t0 VNB 0.05703f
C54 VPWR.n1 VNB 0.13604f
C55 VPWR.n2 VNB 0.05989f
C56 VPWR.n3 VNB 0.00138f
C57 Y.t3 VNB 0.047f
C58 Y.t1 VNB 0.04551f
C59 Y.n0 VNB 0.06528f
C60 Y.t0 VNB 0.02685f
C61 Y.t2 VNB 0.03191f
C62 Y.n1 VNB 0.02247f
C63 Y.n2 VNB 0.00199f
C64 Y.n3 VNB 0.08746f
C65 VGND.t1 VNB 0.02506f
C66 VGND.t0 VNB 0.02136f
C67 VGND.n0 VNB 0.01242f
C68 VGND.n1 VNB 0.03673f
.ends
