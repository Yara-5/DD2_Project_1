* NGSPICE file created from dd2_g5__o22ai_1.ext - technology: sky130A

.subckt dd2_g5__o22ai_1 A B C D VGND VNB VPB VPWR Y
X0 a_407_297.t1 C.t1 Y.t3 VPB.t3 sky130_fd_pr__pfet_01v8_hvt ad=0.265 pd=1.53 as=0.275 ps=1.55 w=1 l=0.15
X1 VGND.t1 A.t0 a_49_47.t1 VNB.t1 sky130_fd_pr__nfet_01v8 ad=0.17225 pd=1.18 as=0.169 ps=1.82 w=0.65 l=0.15
X2 VPWR.t0 D.t1 a_407_297.t0 VPB.t2 sky130_fd_pr__pfet_01v8_hvt ad=0.26 pd=2.52 as=0.265 ps=1.53 w=1 l=0.15
X3 a_49_47.t0 B.t0 VGND.t0 VNB.t0 sky130_fd_pr__nfet_01v8 ad=0.17875 pd=1.2 as=0.17225 ps=1.18 w=0.65 l=0.15
X4 a_49_47.t2 D.t0 Y.t1 VNB.t2 sky130_fd_pr__nfet_01v8 ad=0.169 pd=1.82 as=0.17225 ps=1.18 w=0.65 l=0.15
X5 a_131_297.t1 A.t1 VPWR.t1 VPB.t1 sky130_fd_pr__pfet_01v8_hvt ad=0.265 pd=1.53 as=0.26 ps=2.52 w=1 l=0.15
X6 Y.t0 B.t1 a_131_297.t0 VPB.t0 sky130_fd_pr__pfet_01v8_hvt ad=0.275 pd=1.55 as=0.265 ps=1.53 w=1 l=0.15
X7 Y.t2 C.t0 a_49_47.t3 VNB.t3 sky130_fd_pr__nfet_01v8 ad=0.17225 pd=1.18 as=0.17875 ps=1.2 w=0.65 l=0.15
R0 VGND.n1 VGND.n0 205.309
R1 VGND.n0 VGND.t0 48.9236
R2 VGND.n0 VGND.t1 48.9236
R3 VGND VGND.n1 13.5173
R4 VGND.n1 VGND 0.859413
R5 Y.n2 Y.n0 698.38
R6 Y.n2 Y.n1 185
R7 Y.n0 Y.t3 54.1755
R8 Y.n0 Y.t0 54.1755
R9 Y.n1 Y.t1 48.9236
R10 Y.n1 Y.t2 48.9236
R11 Y Y.n2 5.68939
R12 VPWR.n1 VPWR.t0 888.876
R13 VPWR VPWR.t1 875.817
R14 VPWR.n1 VPWR.n0 31.6916
R15 VPWR.n3 VPWR.n0 10.5417
R16 VPWR.n3 VPWR.n2 9.3005
R17 VPWR VPWR.n3 6.77697
R18 VPWR.n0 VPWR 0.376971
R19 VPWR.n2 VPWR.n1 0.150803
R20 VPWR.n2 VPWR 0.0239375
R21 D.n0 D.t1 241.536
R22 D.n0 D.t0 169.237
R23 D D.n0 155.103
R24 C.n0 C.t1 241.536
R25 C.n0 C.t0 169.237
R26 C C.n0 155.103
R27 B.n0 B.t1 241.536
R28 B.n0 B.t0 169.237
R29 B B.n0 155.103
R30 A.n0 A.t1 241.536
R31 A.n0 A.t0 169.237
R32 A A.n0 155.103
R33 VPB.t0 VPB.t3 414.33
R34 VPB.t3 VPB.t2 402.493
R35 VPB.t1 VPB.t0 402.493
R36 VPB VPB.t1 260.437
R37 VNB.t0 VNB.t3 1993.53
R38 VNB.t3 VNB.t2 1936.57
R39 VNB.t1 VNB.t0 1936.57
R40 VNB VNB.t1 1253.07
R41 a_49_47.n0 a_49_47.t2 503.375
R42 a_49_47.n0 a_49_47.t1 237.708
R43 a_49_47.n1 a_49_47.n0 229.981
R44 a_49_47.n1 a_49_47.t3 50.7697
R45 a_49_47.t0 a_49_47.n1 50.7697
R46 a_407_297.t0 a_407_297.t1 104.41
R47 a_131_297.t0 a_131_297.t1 104.41
C0 Y VPB 0.0083f
C1 C D 0.01429f
C2 C B 0.02147f
C3 VPWR Y 0.02158f
C4 D VPB 0.03344f
C5 VGND Y 0.03011f
C6 B VPB 0.03225f
C7 C VPB 0.03225f
C8 VPWR D 0.0165f
C9 B A 0.01429f
C10 B VPWR 0.01147f
C11 D VGND 0.01682f
C12 B VGND 0.01479f
C13 C VPWR 0.01268f
C14 C VGND 0.01724f
C15 A VPB 0.03367f
C16 VPWR VPB 0.1078f
C17 VGND VPB 0.01238f
C18 VPWR A 0.02089f
C19 VGND A 0.01562f
C20 VPWR VGND 0.03548f
C21 D Y 0.02345f
C22 B Y 0
C23 C Y 0.0391f
C24 VGND VNB 0.59608f
C25 Y VNB 0.01606f
C26 VPWR VNB 0.37205f
C27 D VNB 0.10532f
C28 C VNB 0.0859f
C29 B VNB 0.08637f
C30 A VNB 0.11491f
C31 VPB VNB 0.73754f
C32 a_131_297.t1 VNB 0.04437f
C33 a_131_297.t0 VNB 0.04933f
C34 a_407_297.t1 VNB 0.05034f
C35 a_407_297.t0 VNB 0.04964f
C36 a_49_47.t3 VNB 0.04392f
C37 a_49_47.t2 VNB 0.1453f
C38 a_49_47.t1 VNB 0.06412f
C39 a_49_47.n0 VNB 0.26006f
C40 a_49_47.n1 VNB 0.0591f
C41 a_49_47.t0 VNB 0.04448f
C42 VPB.t2 VNB 0.08916f
C43 VPB.t3 VNB 0.05542f
C44 VPB.t0 VNB 0.05542f
C45 VPB.t1 VNB 0.04498f
C46 A.n0 VNB 0.04087f
C47 B.n0 VNB 0.05085f
C48 C.n0 VNB 0.0493f
C49 D.n0 VNB 0.04789f
C50 VPWR.t1 VNB 0.05115f
C51 VPWR.n0 VNB 0.00779f
C52 VPWR.t0 VNB 0.05505f
C53 VPWR.n1 VNB 0.23309f
C54 VPWR.n2 VNB 0.02798f
C55 VPWR.n3 VNB 0.00256f
C56 Y.t3 VNB 0.05097f
C57 Y.t0 VNB 0.05174f
C58 Y.n0 VNB 0.05852f
C59 Y.t1 VNB 0.03379f
C60 Y.t2 VNB 0.03429f
C61 Y.n1 VNB 0.03317f
C62 Y.n2 VNB 0.05655f
C63 VGND.t0 VNB 0.0271f
C64 VGND.t1 VNB 0.02351f
C65 VGND.n0 VNB 0.01916f
C66 VGND.n1 VNB 0.03986f
.ends
