* Intended schematic from supplied transistor connections.
* SKY130 model files use um-scale W/L convention; load the course model setup.
.subckt dd2_g5__a21o_1 A1 A2 B1 VGND VNB VPB VPWR X
XN1 n1_d1 A1 VGND VNB sky130_fd_pr__nfet_01v8 w=0.65 l=0.15
XN2 n1 A2 n1_d1 VNB sky130_fd_pr__nfet_01v8 w=0.65 l=0.15
XN3 n1 B1 VGND VNB sky130_fd_pr__nfet_01v8 w=0.65 l=0.15
XP1 n1_u1 A1 n1 VPB sky130_fd_pr__pfet_01v8_hvt w=1 l=0.15
XP2 n1_u1 A2 n1 VPB sky130_fd_pr__pfet_01v8_hvt w=1 l=0.15
XP3 VPWR B1 n1_u1 VPB sky130_fd_pr__pfet_01v8_hvt w=1 l=0.15
XN4 X n1 VGND VNB sky130_fd_pr__nfet_01v8 w=0.65 l=0.15
XP4 VPWR n1 X VPB sky130_fd_pr__pfet_01v8_hvt w=1 l=0.15
.ends dd2_g5__a21o_1
