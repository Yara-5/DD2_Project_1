* NGSPICE file created from dd2_g5__a21o_1.ext - technology: sky130A

.subckt dd2_g5__a21o_1 A1 A2 B1 VGND VNB VPB VPWR X
X0 VPWR.t0 B1.t1 a_65_297.t1 VPB.t1 sky130_fd_pr__pfet_01v8_hvt ad=0.165 pd=1.33 as=0.165 ps=1.33 w=1 l=0.15
X1 X.t1 a_147_297.t5 VPWR.t1 VPB.t3 sky130_fd_pr__pfet_01v8_hvt ad=0.26 pd=2.52 as=0.165 ps=1.33 w=1 l=0.15
X2 a_147_297.t3 A2.t0 a_147_47.t1 VNB.t3 sky130_fd_pr__nfet_01v8 ad=0.10725 pd=0.98 as=0.08775 ps=0.92 w=0.65 l=0.15
X3 a_65_297.t2 A2.t1 a_147_297.t2 VPB.t2 sky130_fd_pr__pfet_01v8_hvt ad=0.165 pd=1.33 as=0.135 ps=1.27 w=1 l=0.15
X4 a_147_47.t0 A1.t0 VGND.t1 VNB.t0 sky130_fd_pr__nfet_01v8 ad=0.08775 pd=0.92 as=0.169 ps=1.82 w=0.65 l=0.15
X5 a_147_297.t0 A1.t1 a_65_297.t0 VPB.t0 sky130_fd_pr__pfet_01v8_hvt ad=0.135 pd=1.27 as=0.26 ps=2.52 w=1 l=0.15
X6 X.t0 a_147_297.t4 VGND.t2 VNB.t1 sky130_fd_pr__nfet_01v8 ad=0.169 pd=1.82 as=0.10725 ps=0.98 w=0.65 l=0.15
X7 VGND.t0 B1.t0 a_147_297.t1 VNB.t2 sky130_fd_pr__nfet_01v8 ad=0.10725 pd=0.98 as=0.10725 ps=0.98 w=0.65 l=0.15
R0 VGND.n1 VGND.t1 268.077
R1 VGND.n3 VGND.n2 205.666
R2 VGND.n2 VGND.t0 30.462
R3 VGND.n2 VGND.t2 30.462
R4 VGND.n3 VGND.n1 16.9057
R5 VGND.n5 VGND.n4 9.3005
R6 VGND VGND.n5 6.77697
R7 VGND.n5 VGND.n0 4.14168
R8 VGND.n1 VGND.n0 3.8405
R9 VGND.n0 VGND 3.37505
R10 VGND.n4 VGND.n3 0.327965
R11 VGND.n4 VGND 0.0239375
R12 X.n0 X.t1 895.778
R13 X.n0 X.t0 209.923
R14 X.n1 X 6.4005
R15 X X.n1 3.2005
R16 X.n1 X.n0 0.213833
R17 VPWR.n1 VPWR.n0 619.812
R18 VPWR.n0 VPWR.t1 32.5055
R19 VPWR.n0 VPWR.t0 32.5055
R20 VPWR VPWR.n1 14.3483
R21 VPWR.n1 VPWR 0.0801404
R22 B1.n0 B1.t1 241.536
R23 B1.n0 B1.t0 169.237
R24 B1 B1.n0 155.103
R25 A2.n0 A2.t1 241.536
R26 A2.n0 A2.t0 169.237
R27 A2 A2.n0 155.103
R28 A1.n0 A1.t1 241.536
R29 A1.n0 A1.t0 169.237
R30 A1 A1.n0 155.103
R31 VPB VPB.t0 307.788
R32 VPB.t1 VPB.t3 284.113
R33 VPB.t2 VPB.t1 284.113
R34 VPB.t0 VPB.t2 248.599
R35 VNB VNB.t0 1480.91
R36 VNB.t2 VNB.t1 1366.99
R37 VNB.t3 VNB.t2 1366.99
R38 VNB.t0 VNB.t3 1196.12
R39 a_147_47.t0 a_147_47.t1 49.8467
R40 a_65_297.t0 a_65_297.n0 1504.49
R41 a_65_297.n0 a_65_297.t1 32.5055
R42 a_65_297.n0 a_65_297.t2 32.5055
R43 a_147_297.n3 a_147_297.n2 682.167
R44 a_147_297.n2 a_147_297.n0 248.284
R45 a_147_297.n1 a_147_297.t5 241.536
R46 a_147_297.n1 a_147_297.t4 169.237
R47 a_147_297.n2 a_147_297.n1 152
R48 a_147_297.n0 a_147_297.t1 30.462
R49 a_147_297.n0 a_147_297.t3 30.462
R50 a_147_297.n3 a_147_297.t2 26.5955
R51 a_147_297.t0 a_147_297.n3 26.5955
C0 A1 VGND 0.02299f
C1 A2 B1 0.03636f
C2 VPWR A1 0.00982f
C3 A2 VGND 0.01936f
C4 VPB X 0.0118f
C5 VPWR A2 0.00971f
C6 VPB B1 0.0268f
C7 X B1 0.0013f
C8 A2 A1 0.03922f
C9 VPB VGND 0.01685f
C10 X VGND 0.02266f
C11 VPWR VPB 0.08883f
C12 VPWR X 0.01942f
C13 VGND B1 0.01669f
C14 VPWR B1 0.01681f
C15 VPB A1 0.0308f
C16 VPWR VGND 0.03137f
C17 A2 VPB 0.02591f
C18 A2 X 0
C19 VGND VNB 0.38789f
C20 X VNB 0.05765f
C21 VPWR VNB 0.39514f
C22 B1 VNB 0.0773f
C23 A2 VNB 0.07506f
C24 A1 VNB 0.1085f
C25 VPB VNB 0.65306f
C26 a_147_297.t2 VNB 0.04341f
C27 a_147_297.t1 VNB 0.03483f
C28 a_147_297.t3 VNB 0.03261f
C29 a_147_297.n0 VNB 0.03511f
C30 a_147_297.n1 VNB 0.03899f
C31 a_147_297.n2 VNB 0.12579f
C32 a_147_297.n3 VNB 0.04007f
C33 a_147_297.t0 VNB 0.03679f
C34 a_65_297.t1 VNB 0.04587f
C35 a_65_297.t2 VNB 0.0428f
C36 a_65_297.n0 VNB 0.06041f
C37 a_65_297.t0 VNB 0.08573f
C38 a_147_47.t1 VNB 0.02723f
C39 a_147_47.t0 VNB 0.02245f
C40 VPB.t3 VNB 0.09413f
C41 VPB.t1 VNB 0.03929f
C42 VPB.t2 VNB 0.03683f
C43 VPB.t0 VNB 0.03847f
C44 A1.n0 VNB 0.03942f
C45 A2.n0 VNB 0.05273f
C46 B1.n0 VNB 0.05892f
C47 VPWR.t1 VNB 0.03104f
C48 VPWR.t0 VNB 0.04084f
C49 VPWR.n0 VNB 0.02395f
C50 VPWR.n1 VNB 0.16096f
C51 X.t1 VNB 0.05824f
C52 X.t0 VNB 0.0384f
C53 X.n0 VNB 0.04286f
C54 X.n1 VNB 0.00505f
C55 VGND.n0 VNB 0.0083f
C56 VGND.t1 VNB 0.028f
C57 VGND.n1 VNB 0.01616f
C58 VGND.t2 VNB 0.01902f
C59 VGND.t0 VNB 0.02611f
C60 VGND.n2 VNB 0.01129f
C61 VGND.n3 VNB 0.08074f
C62 VGND.n4 VNB 0.07525f
C63 VGND.n5 VNB 0.00114f
.ends
