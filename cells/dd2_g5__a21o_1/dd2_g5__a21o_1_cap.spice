* NGSPICE file created from dd2_g5__a21o_1.ext - technology: sky130A

.subckt dd2_g5__a21o_1 A1 A2 B1 VGND VNB VPB VPWR X
X0 VPWR B1 a_65_297# VPB sky130_fd_pr__pfet_01v8_hvt ad=0.165 pd=1.33 as=0.165 ps=1.33 w=1 l=0.15
X1 X a_147_297# VPWR VPB sky130_fd_pr__pfet_01v8_hvt ad=0.26 pd=2.52 as=0.165 ps=1.33 w=1 l=0.15
X2 a_147_297# A2 a_147_47# VNB sky130_fd_pr__nfet_01v8 ad=0.10725 pd=0.98 as=0.08775 ps=0.92 w=0.65 l=0.15
X3 a_65_297# A2 a_147_297# VPB sky130_fd_pr__pfet_01v8_hvt ad=0.165 pd=1.33 as=0.135 ps=1.27 w=1 l=0.15
X4 a_147_47# A1 VGND VNB sky130_fd_pr__nfet_01v8 ad=0.08775 pd=0.92 as=0.169 ps=1.82 w=0.65 l=0.15
X5 a_147_297# A1 a_65_297# VPB sky130_fd_pr__pfet_01v8_hvt ad=0.135 pd=1.27 as=0.26 ps=2.52 w=1 l=0.15
X6 X a_147_297# VGND VNB sky130_fd_pr__nfet_01v8 ad=0.169 pd=1.82 as=0.10725 ps=0.98 w=0.65 l=0.15
X7 VGND B1 a_147_297# VNB sky130_fd_pr__nfet_01v8 ad=0.10725 pd=0.98 as=0.10725 ps=0.98 w=0.65 l=0.15
C0 X VGND 0.02257f
C1 VGND A2 0.02116f
C2 a_147_297# a_147_47# 0.00472f
C3 VPWR VPB 0.0899f
C4 a_147_47# A2 0
C5 a_147_47# VGND 0.01289f
C6 VPB a_65_297# 0.01409f
C7 VPB B1 0.0268f
C8 VPWR a_65_297# 0.10615f
C9 VPWR B1 0.01972f
C10 a_147_297# VPB 0.04289f
C11 VPB A1 0.0308f
C12 B1 a_65_297# 0.00511f
C13 VPWR a_147_297# 0.05245f
C14 VPWR A1 0.00929f
C15 X VPB 0.0164f
C16 VPB A2 0.02591f
C17 a_147_297# a_65_297# 0.04951f
C18 a_147_297# B1 0.08139f
C19 A1 a_65_297# 0.02371f
C20 VPB VGND 0.01565f
C21 VPWR X 0.03264f
C22 VPWR A2 0.00971f
C23 VPWR VGND 0.0311f
C24 a_147_297# A1 0.00422f
C25 X a_65_297# 0.00102f
C26 X B1 0.00134f
C27 A2 a_65_297# 0.01396f
C28 A2 B1 0.03636f
C29 VGND a_65_297# 0.00817f
C30 VGND B1 0.01676f
C31 X a_147_297# 0.05707f
C32 a_147_297# A2 0.02256f
C33 VPWR a_147_47# 0.00122f
C34 X A1 0
C35 A1 A2 0.03922f
C36 a_147_297# VGND 0.08008f
C37 A1 VGND 0.02809f
C38 a_147_47# a_65_297# 0
C39 X A2 0
C40 VGND VNB 0.44633f
C41 X VNB 0.13138f
C42 VPWR VNB 0.37076f
C43 VPB VNB 0.60476f
C44 a_147_47# VNB 0.07466f
C45 a_65_297# VNB 0.05666f
.ends
