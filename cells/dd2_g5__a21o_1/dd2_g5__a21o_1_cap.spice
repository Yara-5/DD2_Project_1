* NGSPICE file created from dd2_g5__a21o_1.ext - technology: sky130A

.subckt dd2_g5__a21o_1 A1 A2 B1 VGND VNB VPB VPWR X
X0 VPWR B1 a_65_297# VPB sky130_fd_pr__pfet_01v8_hvt ad=0.165 pd=1.33 as=0.165 ps=1.33 w=1 l=0.15
X1 X a_147_297# VPWR VPB sky130_fd_pr__pfet_01v8_hvt ad=0.26 pd=2.52 as=0.165 ps=1.33 w=1 l=0.15
X2 a_147_297# A2 a_147_47# VNB sky130_fd_pr__nfet_01v8 ad=0.10725 pd=0.98 as=0.08775 ps=0.92 w=0.65 l=0.15
X3 a_65_297# A2 a_147_297# VPB sky130_fd_pr__pfet_01v8_hvt ad=0.165 pd=1.33 as=0.135 ps=1.27 w=1 l=0.15
X4 a_147_47# A1 VGND VNB sky130_fd_pr__nfet_01v8 ad=0.08775 pd=0.92 as=0.169 ps=1.82 w=0.65 l=0.15
X5 a_147_297# A1 a_65_297# VPB sky130_fd_pr__pfet_01v8_hvt ad=0.135 pd=1.27 as=0.26 ps=2.52 w=1 l=0.15
X6 X a_147_297# VGND VNB sky130_fd_pr__nfet_01v8 ad=0.169 pd=1.82 as=0.10725 ps=0.98 w=0.65 l=0.15
X7 VGND B1 a_147_297# VNB sky130_fd_pr__nfet_01v8 ad=0.10725 pd=0.98 as=0.10725 ps=0.98 w=0.65 l=0.15
C0 VPWR a_65_297# 0.08412f
C1 VPWR B1 0.01681f
C2 a_147_297# VPB 0.04571f
C3 VPB A1 0.0308f
C4 B1 a_65_297# 0.00161f
C5 VPWR a_147_297# 0.04745f
C6 VPWR A1 0.00982f
C7 X VPB 0.0118f
C8 VPB A2 0.02591f
C9 a_147_297# a_65_297# 0.03253f
C10 a_147_297# B1 0.08139f
C11 A1 a_65_297# 0.01336f
C12 VPB VGND 0.01685f
C13 VPWR X 0.01942f
C14 VPWR A2 0.00971f
C15 VPWR VGND 0.03137f
C16 a_147_297# A1 0.00488f
C17 X a_65_297# 0
C18 X B1 0.0013f
C19 A2 a_65_297# 0.00839f
C20 A2 B1 0.03636f
C21 VGND a_65_297# 0.00831f
C22 VGND B1 0.01669f
C23 X a_147_297# 0.05402f
C24 a_147_297# A2 0.02256f
C25 VPWR a_147_47# 0.00122f
C26 A1 A2 0.03922f
C27 a_147_297# VGND 0.07555f
C28 A1 VGND 0.02299f
C29 a_147_47# a_65_297# 0
C30 X A2 0
C31 X VGND 0.02266f
C32 VGND A2 0.01936f
C33 a_147_297# a_147_47# 0.00472f
C34 VPWR VPB 0.08883f
C35 a_147_47# A2 0
C36 a_147_47# VGND 0.01025f
C37 VPB a_65_297# 0.01032f
C38 VPB B1 0.0268f
C39 VGND VNB 0.43281f
C40 X VNB 0.12829f
C41 VPWR VNB 0.37962f
C42 VPB VNB 0.60476f
C43 a_147_47# VNB 0.07466f
C44 a_65_297# VNB 0.03455f
.ends
