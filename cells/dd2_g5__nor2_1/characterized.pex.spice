* NGSPICE file created from dd2_g5__nor2_1.ext - technology: sky130A

.subckt dd2_g5__nor2_1 A B VGND VNB VPB VPWR Y
X0 a_111_297.t1 A.t1 VPWR.t0 VPB.t1 sky130_fd_pr__pfet_01v8_hvt ad=0.135 pd=1.27 as=0.26 ps=2.52 w=1 l=0.15
X1 VGND.t0 B.t0 Y.t0 VNB.t0 sky130_fd_pr__nfet_01v8 ad=0.169 pd=1.82 as=0.08775 ps=0.92 w=0.65 l=0.15
X2 Y.t1 A.t0 VGND.t1 VNB.t1 sky130_fd_pr__nfet_01v8 ad=0.08775 pd=0.92 as=0.169 ps=1.82 w=0.65 l=0.15
X3 Y.t2 B.t1 a_111_297.t0 VPB.t0 sky130_fd_pr__pfet_01v8_hvt ad=0.26 pd=2.52 as=0.135 ps=1.27 w=1 l=0.15
R0 VGND.n1 VGND.t1 282.817
R1 VGND.n0 VGND.t0 156.162
R2 VGND.n1 VGND.n0 6.23999
R3 VGND VGND.n1 3.10353
R4 VGND.n0 VGND 0.65867
R5 Y.n1 Y.t2 314.289
R6 Y.n1 Y.n0 185
R7 Y.n0 Y.t0 24.9236
R8 Y.n0 Y.t1 24.9236
R9 Y.n2 Y 6.4005
R10 Y Y.n2 3.69281
R11 Y.n2 Y.n1 0.246654
R12 VPWR VPWR.t0 347.193
R13 VPWR VPWR.n0 7.31888
R14 VPWR.n0 VPWR 7.11121
R15 VPWR.n0 VPWR 2.67249
R16 B.n0 B.t1 241.536
R17 B.n0 B.t0 169.237
R18 B B.n0 155.103
R19 A.n0 A.t1 230.155
R20 A.n0 A.t0 157.856
R21 A A.n0 155.103
R22 VPB.t1 VPB.t0 248.599
R23 VPB VPB.t1 201.246
R24 VNB.t1 VNB.t0 1196.12
R25 VNB VNB.t1 968.285
R26 a_111_297.t0 a_111_297.t1 53.1905
C0 A VPB 0.0375f
C1 VPWR Y 0.04843f
C2 A B 0.02626f
C3 Y VPB 0.01617f
C4 Y B 0.04793f
C5 A VGND 0.02797f
C6 Y VGND 0.0441f
C7 VPWR VPB 0.05055f
C8 VPWR B 0.01471f
C9 B VPB 0.02935f
C10 VPWR VGND 0.01944f
C11 VPB VGND 0.00706f
C12 A Y 0.03513f
C13 B VGND 0.02774f
C14 VPWR A 0.02841f
C15 VGND VNB 0.29597f
C16 Y VNB 0.0805f
C17 VPWR VNB 0.33275f
C18 B VNB 0.11286f
C19 A VNB 0.1289f
C20 VPB VNB 0.37893f
C21 a_111_297.t1 VNB 0.03675f
C22 a_111_297.t0 VNB 0.03821f
C23 VPB.t0 VNB 0.07032f
C24 VPB.t1 VNB 0.03036f
C25 A.n0 VNB 0.06276f
C26 B.n0 VNB 0.04753f
C27 VPWR.t0 VNB 0.05659f
C28 VPWR.n0 VNB 0.00283f
C29 Y.t2 VNB 0.09836f
C30 Y.t0 VNB 0.02622f
C31 Y.t1 VNB 0.02513f
C32 Y.n0 VNB 0.01829f
C33 Y.n1 VNB 0.0886f
C34 Y.n2 VNB 0.00634f
C35 VGND.t0 VNB 0.03106f
C36 VGND.n0 VNB 0.03254f
C37 VGND.t1 VNB 0.02846f
C38 VGND.n1 VNB 0.01825f
.ends
