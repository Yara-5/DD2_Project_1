* NGSPICE file created from dd2_g5__nor2_1.ext - technology: sky130A

.subckt dd2_g5__nor2_1 A B VGND VNB VPB VPWR Y
X0 a_111_297# A VPWR VPB sky130_fd_pr__pfet_01v8_hvt ad=0.135 pd=1.27 as=0.26 ps=2.52 w=1 l=0.15
X1 VGND B Y VNB sky130_fd_pr__nfet_01v8 ad=0.169 pd=1.82 as=0.08775 ps=0.92 w=0.65 l=0.15
X2 Y A VGND VNB sky130_fd_pr__nfet_01v8 ad=0.08775 pd=0.92 as=0.169 ps=1.82 w=0.65 l=0.15
X3 Y B a_111_297# VPB sky130_fd_pr__pfet_01v8_hvt ad=0.26 pd=2.52 as=0.135 ps=1.27 w=1 l=0.15
C0 B Y 0.04793f
C1 VPB VPWR 0.05055f
C2 VPWR A 0.02841f
C3 VPB VGND 0.00706f
C4 VGND A 0.02797f
C5 B VPWR 0.01471f
C6 Y VPWR 0.04843f
C7 a_111_297# Y 0.01398f
C8 B VGND 0.02774f
C9 Y VGND 0.0441f
C10 VPB A 0.0375f
C11 a_111_297# VPWR 0.01356f
C12 VGND VPWR 0.01944f
C13 a_111_297# VGND 0.00165f
C14 B VPB 0.02935f
C15 VPB Y 0.01617f
C16 B A 0.02626f
C17 Y A 0.03513f
C18 VGND VNB 0.29044f
C19 Y VNB 0.12752f
C20 VPWR VNB 0.25076f
C21 VPB VNB 0.33898f
C22 a_111_297# VNB 0.05596f
.ends
