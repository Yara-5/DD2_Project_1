* NGSPICE file created from dd2_g5__mux2_opt_1.ext - technology: sky130A

.subckt dd2_g5__mux2_opt_1 A B C VGND VNB VPB VPWR Y
X0 Y a_127_47# a_233_297# VPB sky130_fd_pr__pfet_01v8_hvt ad=0.155 pd=1.31 as=0.26 ps=2.52 w=1 l=0.15
X1 a_501_199# C VGND VNB sky130_fd_pr__nfet_01v8 ad=0.16695 pd=1.16 as=0.17575 ps=1.2 w=0.63 l=0.15
X2 VGND A a_501_199# VNB sky130_fd_pr__nfet_01v8 ad=0.1638 pd=1.78 as=0.16695 ps=1.16 w=0.63 l=0.15
X3 a_233_297# C Y VPB sky130_fd_pr__pfet_01v8_hvt ad=0.265 pd=1.53 as=0.155 ps=1.31 w=1 l=0.15
X4 a_127_47# B VGND VNB sky130_fd_pr__nfet_01v8 ad=0.1092 pd=1.36 as=0.1092 ps=1.36 w=0.42 l=0.15
X5 a_315_47# a_127_47# VGND VNB sky130_fd_pr__nfet_01v8 ad=0.10075 pd=0.96 as=0.169 ps=1.82 w=0.65 l=0.15
X6 a_127_47# B VPWR VPB sky130_fd_pr__pfet_01v8_hvt ad=0.1092 pd=1.36 as=0.1092 ps=1.36 w=0.42 l=0.15
X7 VPWR a_501_199# a_233_297# VPB sky130_fd_pr__pfet_01v8_hvt ad=0.227 pd=1.55 as=0.265 ps=1.53 w=1 l=0.15
X8 VGND a_501_199# Y VNB sky130_fd_pr__nfet_01v8 ad=0.17575 pd=1.2 as=0.17225 ps=1.18 w=0.65 l=0.15
X9 a_683_361# C VPWR VPB sky130_fd_pr__pfet_01v8_hvt ad=0.1802 pd=1.21 as=0.227 ps=1.55 w=0.68 l=0.15
X10 a_501_199# A a_683_361# VPB sky130_fd_pr__pfet_01v8_hvt ad=0.1768 pd=1.88 as=0.1802 ps=1.21 w=0.68 l=0.15
X11 Y C a_315_47# VNB sky130_fd_pr__nfet_01v8 ad=0.17225 pd=1.18 as=0.10075 ps=0.96 w=0.65 l=0.15
C0 a_233_297# a_127_47# 0.04047f
C1 VPWR a_501_199# 0.0601f
C2 B Y 0.00109f
C3 B C 0.00138f
C4 a_683_361# a_501_199# 0.01549f
C5 B VGND 0.02229f
C6 a_233_297# a_315_47# 0
C7 a_683_361# VPWR 0.02236f
C8 Y a_501_199# 0.0161f
C9 a_501_199# C 0.13638f
C10 VPWR Y 0.0101f
C11 VGND a_501_199# 0.1293f
C12 a_501_199# A 0.05217f
C13 VPWR C 0.0609f
C14 VPB a_233_297# 0.01048f
C15 VGND VPWR 0.05339f
C16 VPWR A 0.01488f
C17 B a_127_47# 0.05019f
C18 a_683_361# Y 0
C19 VGND a_683_361# 0.00253f
C20 Y C 0.06062f
C21 a_127_47# a_501_199# 0
C22 VGND Y 0.05317f
C23 Y A 0
C24 VGND C 0.03578f
C25 C A 0.01942f
C26 VPWR a_127_47# 0.04051f
C27 VGND A 0.02558f
C28 VPB B 0.09354f
C29 a_683_361# a_127_47# 0
C30 a_501_199# a_315_47# 0
C31 VPWR a_315_47# 0
C32 Y a_127_47# 0.05077f
C33 a_127_47# C 0.02516f
C34 VPB a_501_199# 0.06465f
C35 VGND a_127_47# 0.06555f
C36 a_127_47# A 0
C37 VPB VPWR 0.14862f
C38 B a_233_297# 0
C39 Y a_315_47# 0.00948f
C40 C a_315_47# 0
C41 a_233_297# a_501_199# 0.00483f
C42 VGND a_315_47# 0.00826f
C43 VPWR a_233_297# 0.11494f
C44 VPB Y 0.00931f
C45 VPB C 0.10585f
C46 VPB VGND 0.0224f
C47 VPB A 0.0592f
C48 a_127_47# a_315_47# 0
C49 a_233_297# Y 0.02559f
C50 a_233_297# C 0.03812f
C51 VGND a_233_297# 0.00734f
C52 VPB a_127_47# 0.06863f
C53 B a_501_199# 0
C54 B VPWR 0.02067f
C55 VGND VNB 0.81276f
C56 Y VNB 0.07896f
C57 VPWR VNB 0.57217f
C58 VPB VNB 0.95915f
C59 a_315_47# VNB 0.03604f
C60 a_233_297# VNB 0.19411f
.ends
