* dd2_g5__mux2_opt_1: Y = (A | C) & (B | !C)
* Generated by synthesize.py; stages in signal order:
*   B_N = !(B)
*   n1 = !(A | C)
*   Y = !(n1 | (B_N & C))
.subckt dd2_g5__mux2_opt_1 A B C VGND VNB VPB VPWR Y
XN1 B_N B VGND VNB sky130_fd_pr__nfet_01v8 w=0.42 l=0.15
XP1 B_N B VPWR VPB sky130_fd_pr__pfet_01v8_hvt w=0.42 l=0.15
XN2 n1 A VGND VNB sky130_fd_pr__nfet_01v8 w=0.63 l=0.15
XN3 n1 C VGND VNB sky130_fd_pr__nfet_01v8 w=0.63 l=0.15
XP2 n1_u1 A VPWR VPB sky130_fd_pr__pfet_01v8_hvt w=0.68 l=0.15
XP3 n1 C n1_u1 VPB sky130_fd_pr__pfet_01v8_hvt w=0.68 l=0.15
XN4 Y n1 VGND VNB sky130_fd_pr__nfet_01v8 w=0.65 l=0.15
XN5 Y B_N Y_d1 VNB sky130_fd_pr__nfet_01v8 w=0.65 l=0.15
XN6 Y_d1 C VGND VNB sky130_fd_pr__nfet_01v8 w=0.65 l=0.15
XP4 Y_u1 n1 VPWR VPB sky130_fd_pr__pfet_01v8_hvt w=1 l=0.15
XP5 Y B_N Y_u1 VPB sky130_fd_pr__pfet_01v8_hvt w=1 l=0.15
XP6 Y C Y_u1 VPB sky130_fd_pr__pfet_01v8_hvt w=1 l=0.15
.ends dd2_g5__mux2_opt_1
