* Intended schematic from supplied transistor connections.
* SKY130 model files use um-scale W/L convention; load the course model setup.
.subckt dd2_g5__mux2_opt_1 A B C VGND VNB VPB VPWR Y
XN1 B_N B VGND VNB sky130_fd_pr__nfet_01v8 w=0.42 l=0.15
XP1 VPWR B B_N VPB sky130_fd_pr__pfet_01v8_hvt w=0.42 l=0.15
XN2 n1 A VGND VNB sky130_fd_pr__nfet_01v8 w=0.63 l=0.15
XN3 n1 C VGND VNB sky130_fd_pr__nfet_01v8 w=0.63 l=0.15
XP2 n1_u1 A n1 VPB sky130_fd_pr__pfet_01v8_hvt w=0.68 l=0.15
XP3 VPWR C n1_u1 VPB sky130_fd_pr__pfet_01v8_hvt w=0.68 l=0.15
XN4 Y n1 VGND VNB sky130_fd_pr__nfet_01v8 w=0.65 l=0.15
XN5 Y_d1 B_N VGND VNB sky130_fd_pr__nfet_01v8 w=0.65 l=0.15
XN6 Y C Y_d1 VNB sky130_fd_pr__nfet_01v8 w=0.65 l=0.15
XP4 VPWR n1 Y_u1 VPB sky130_fd_pr__pfet_01v8_hvt w=1 l=0.15
XP5 Y_u1 B_N Y VPB sky130_fd_pr__pfet_01v8_hvt w=1 l=0.15
XP6 Y_u1 C Y VPB sky130_fd_pr__pfet_01v8_hvt w=1 l=0.15
.ends dd2_g5__mux2_opt_1
