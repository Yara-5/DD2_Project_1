* NGSPICE file created from dd2_g5__mux2_opt_1.ext - technology: sky130A

.subckt dd2_g5__mux2_opt_1 A B C VGND VNB VPB VPWR Y
X0 Y.t3 a_127_47.t3 a_233_297.t1 VPB.t2 sky130_fd_pr__pfet_01v8_hvt ad=0.155 pd=1.31 as=0.26 ps=2.52 w=1 l=0.15
X1 a_501_199.t2 C.t0 VGND.t2 VNB.t5 sky130_fd_pr__nfet_01v8 ad=0.16695 pd=1.16 as=0.17575 ps=1.2 w=0.63 l=0.15
X2 VGND.t0 A.t0 a_501_199.t0 VNB.t3 sky130_fd_pr__nfet_01v8 ad=0.1638 pd=1.78 as=0.16695 ps=1.16 w=0.63 l=0.15
X3 a_233_297.t2 C.t3 Y.t2 VPB.t4 sky130_fd_pr__pfet_01v8_hvt ad=0.265 pd=1.53 as=0.155 ps=1.31 w=1 l=0.15
X4 a_127_47.t1 B.t0 VGND.t4 VNB.t0 sky130_fd_pr__nfet_01v8 ad=0.1092 pd=1.36 as=0.1092 ps=1.36 w=0.42 l=0.15
X5 a_315_47.t0 a_127_47.t2 VGND.t3 VNB.t2 sky130_fd_pr__nfet_01v8 ad=0.10075 pd=0.96 as=0.169 ps=1.82 w=0.65 l=0.15
X6 a_127_47.t0 B.t1 VPWR.t2 VPB.t0 sky130_fd_pr__pfet_01v8_hvt ad=0.1092 pd=1.36 as=0.1092 ps=1.36 w=0.42 l=0.15
X7 VPWR.t1 a_501_199.t4 a_233_297.t0 VPB.t1 sky130_fd_pr__pfet_01v8_hvt ad=0.227 pd=1.55 as=0.265 ps=1.53 w=1 l=0.15
X8 VGND.t1 a_501_199.t3 Y.t0 VNB.t1 sky130_fd_pr__nfet_01v8 ad=0.17575 pd=1.2 as=0.17225 ps=1.18 w=0.65 l=0.15
X9 a_683_361.t1 C.t2 VPWR.t0 VPB.t5 sky130_fd_pr__pfet_01v8_hvt ad=0.1802 pd=1.21 as=0.227 ps=1.55 w=0.68 l=0.15
X10 a_501_199.t1 A.t1 a_683_361.t0 VPB.t3 sky130_fd_pr__pfet_01v8_hvt ad=0.1768 pd=1.88 as=0.1802 ps=1.21 w=0.68 l=0.15
X11 Y.t1 C.t1 a_315_47.t1 VNB.t4 sky130_fd_pr__nfet_01v8 ad=0.17225 pd=1.18 as=0.10075 ps=0.96 w=0.65 l=0.15
R0 VGND.n10 VGND.t3 282.817
R1 VGND.n14 VGND.t4 238.311
R2 VGND.n4 VGND.n3 199.739
R3 VGND.n5 VGND.t0 156.081
R4 VGND.n3 VGND.t2 52.3815
R5 VGND.n3 VGND.t1 49.0509
R6 VGND.n9 VGND.n8 34.6358
R7 VGND.n8 VGND.n2 34.6358
R8 VGND.n10 VGND.n0 32.7534
R9 VGND.n4 VGND.n2 22.2123
R10 VGND.n14 VGND.n0 13.177
R11 VGND.n10 VGND.n9 11.6711
R12 VGND.n6 VGND.n2 9.3005
R13 VGND.n8 VGND.n7 9.3005
R14 VGND.n9 VGND.n1 9.3005
R15 VGND.n11 VGND.n10 9.3005
R16 VGND.n12 VGND.n0 9.3005
R17 VGND.n14 VGND.n13 9.3005
R18 VGND.n5 VGND.n4 6.93613
R19 VGND.n14 VGND 5.53564
R20 VGND VGND.n14 3.10353
R21 VGND.n6 VGND.n5 0.280421
R22 VGND.n13 VGND.n12 0.120292
R23 VGND.n12 VGND.n11 0.120292
R24 VGND.n11 VGND.n1 0.120292
R25 VGND.n7 VGND.n1 0.120292
R26 VGND.n7 VGND.n6 0.120292
R27 VGND.n13 VGND 0.0239375
R28 Y Y.n1 686.611
R29 Y Y.n0 191.024
R30 Y.n0 Y.t0 48.9236
R31 Y.n0 Y.t1 48.9236
R32 Y.n1 Y.t2 30.5355
R33 Y.n1 Y.t3 30.5355
R34 VPWR VPWR.t2 670.158
R35 VPWR.n2 VPWR.n1 327.969
R36 VPWR.n1 VPWR.t0 79.6696
R37 VPWR.n1 VPWR.t1 72.3044
R38 VPWR.n2 VPWR.n0 33.1997
R39 VPWR.n4 VPWR.n3 9.3005
R40 VPWR.n4 VPWR.n0 9.03579
R41 VPWR VPWR.n4 6.77697
R42 VPWR.n0 VPWR 0.376971
R43 VPWR.n3 VPWR.n2 0.148621
R44 VPWR.n3 VPWR 0.0239375
R45 A.n0 A.t1 292.95
R46 A.n0 A.t0 172.45
R47 A A.n0 155.103
R48 C.n0 C.t2 292.95
R49 C.n2 C.n0 285.497
R50 C.n1 C.t3 241.536
R51 C.n0 C.t0 172.45
R52 C.n1 C.t1 169.237
R53 C.n2 C.n1 152
R54 C C.n2 4.0965
R55 B.n0 B.t1 334.723
R56 B.n0 B.t0 206.19
R57 B B.n0 155.103
R58 VPB.t0 VPB.t2 556.386
R59 VPB.t1 VPB.t5 414.33
R60 VPB.t5 VPB.t3 402.493
R61 VPB.t4 VPB.t1 402.493
R62 VPB.t2 VPB.t4 272.274
R63 VPB VPB.t0 248.599
R64 VNB.t0 VNB.t2 2677.02
R65 VNB.t1 VNB.t5 1993.53
R66 VNB.t5 VNB.t3 1936.57
R67 VNB.t4 VNB.t1 1936.57
R68 VNB.t2 VNB.t4 1310.03
R69 VNB VNB.t0 1196.12
R70 a_315_47.t0 a_315_47.t1 57.2313
R71 a_683_361.t0 a_683_361.t1 153.544
R72 a_233_297.n0 a_233_297.t1 669.317
R73 a_233_297.t0 a_233_297.n0 52.2055
R74 a_233_297.n0 a_233_297.t2 52.2055
R75 a_501_199.n1 a_501_199.t1 479.192
R76 a_501_199.n1 a_501_199.n0 243.107
R77 a_501_199.n0 a_501_199.t4 241.536
R78 a_501_199.n0 a_501_199.t3 169.237
R79 a_501_199.n2 a_501_199.n1 97.6819
R80 a_501_199.t0 a_501_199.n2 50.4767
R81 a_501_199.n2 a_501_199.t2 50.4767
R82 a_127_47.t0 a_127_47.n1 709.177
R83 a_127_47.n1 a_127_47.t1 254.309
R84 a_127_47.n0 a_127_47.t3 229.754
R85 a_127_47.n1 a_127_47.n0 165.577
R86 a_127_47.n0 a_127_47.t2 157.453
C0 VGND VPWR 0.05339f
C1 VGND VPB 0.0224f
C2 Y B 0.00109f
C3 VGND C 0.03578f
C4 VPWR VPB 0.14862f
C5 C VPWR 0.0609f
C6 C VPB 0.10585f
C7 VGND Y 0.05317f
C8 Y VPWR 0.0101f
C9 Y VPB 0.00931f
C10 VGND A 0.02558f
C11 Y C 0.06062f
C12 VPWR A 0.01488f
C13 A VPB 0.0592f
C14 C A 0.01942f
C15 VGND B 0.02229f
C16 Y A 0
C17 B VPWR 0.02067f
C18 B VPB 0.09354f
C19 C B 0.00138f
C20 VGND VNB 0.60111f
C21 Y VNB 0.09246f
C22 VPWR VNB 0.47627f
C23 A VNB 0.12899f
C24 C VNB 0.1439f
C25 B VNB 0.16677f
C26 VPB VNB 1.02233f
C27 a_127_47.t1 VNB 0.05087f
C28 a_127_47.n0 VNB 0.06354f
C29 a_127_47.n1 VNB 0.1428f
C30 a_127_47.t0 VNB 0.05795f
C31 a_501_199.n0 VNB 0.05735f
C32 a_501_199.t1 VNB 0.08617f
C33 a_501_199.n1 VNB 0.19316f
C34 a_501_199.t2 VNB 0.04374f
C35 a_501_199.n2 VNB 0.04893f
C36 a_501_199.t0 VNB 0.04314f
C37 a_233_297.t1 VNB 0.11321f
C38 a_233_297.t2 VNB 0.05445f
C39 a_233_297.n0 VNB 0.09924f
C40 a_233_297.t0 VNB 0.04717f
C41 a_683_361.t1 VNB 0.04648f
C42 a_683_361.t0 VNB 0.04571f
C43 a_315_47.t1 VNB 0.03047f
C44 a_315_47.t0 VNB 0.0253f
C45 VPB.t3 VNB 0.12987f
C46 VPB.t5 VNB 0.08073f
C47 VPB.t1 VNB 0.08073f
C48 VPB.t4 VNB 0.06669f
C49 VPB.t2 VNB 0.0819f
C50 VPB.t0 VNB 0.07956f
C51 B.n0 VNB 0.07466f
C52 C.n0 VNB 0.09701f
C53 C.n1 VNB 0.05717f
C54 C.n2 VNB 0.13341f
C55 A.n0 VNB 0.06055f
C56 VPWR.t2 VNB 0.04132f
C57 VPWR.n0 VNB 0.00857f
C58 VPWR.t0 VNB 0.03983f
C59 VPWR.t1 VNB 0.04129f
C60 VPWR.n1 VNB 0.03495f
C61 VPWR.n2 VNB 0.39344f
C62 VPWR.n3 VNB 0.02951f
C63 VPWR.n4 VNB 0.00259f
C64 Y.t0 VNB 0.03511f
C65 Y.t1 VNB 0.04037f
C66 Y.n0 VNB 0.03981f
C67 Y.t2 VNB 0.04631f
C68 Y.t3 VNB 0.0392f
C69 Y.n1 VNB 0.04181f
C70 VGND.n0 VNB 0.00502f
C71 VGND.t4 VNB 0.03028f
C72 VGND.n1 VNB 0.02137f
C73 VGND.n2 VNB 0.00621f
C74 VGND.t0 VNB 0.03655f
C75 VGND.t2 VNB 0.02888f
C76 VGND.t1 VNB 0.02281f
C77 VGND.n3 VNB 0.01885f
C78 VGND.n4 VNB 0.02338f
C79 VGND.n5 VNB 0.08596f
C80 VGND.n6 VNB 0.06282f
C81 VGND.n7 VNB 0.02137f
C82 VGND.n8 VNB 0.00757f
C83 VGND.n9 VNB 0.00506f
C84 VGND.t3 VNB 0.03055f
C85 VGND.n10 VNB 0.0237f
C86 VGND.n11 VNB 0.02137f
C87 VGND.n12 VNB 0.02137f
C88 VGND.n13 VNB 0.01278f
C89 VGND.n14 VNB 0.02053f
.ends
