* NGSPICE file created from dd2_g5__mux2_opt_1.ext - technology: sky130A

.subckt dd2_g5__mux2_opt_1 A B C VGND VNB VPB VPWR Y
X0 Y a_127_47# a_233_297# VPB sky130_fd_pr__pfet_01v8_hvt ad=0.155 pd=1.31 as=0.26 ps=2.52 w=1 l=0.15
X1 a_501_199# C VGND VNB sky130_fd_pr__nfet_01v8 ad=0.16695 pd=1.16 as=0.17575 ps=1.2 w=0.63 l=0.15
X2 VGND A a_501_199# VNB sky130_fd_pr__nfet_01v8 ad=0.1638 pd=1.78 as=0.16695 ps=1.16 w=0.63 l=0.15
X3 a_233_297# C Y VPB sky130_fd_pr__pfet_01v8_hvt ad=0.265 pd=1.53 as=0.155 ps=1.31 w=1 l=0.15
X4 a_127_47# B VGND VNB sky130_fd_pr__nfet_01v8 ad=0.1092 pd=1.36 as=0.1092 ps=1.36 w=0.42 l=0.15
X5 a_315_47# a_127_47# VGND VNB sky130_fd_pr__nfet_01v8 ad=0.10075 pd=0.96 as=0.169 ps=1.82 w=0.65 l=0.15
X6 a_127_47# B VPWR VPB sky130_fd_pr__pfet_01v8_hvt ad=0.1092 pd=1.36 as=0.1092 ps=1.36 w=0.42 l=0.15
X7 VPWR a_501_199# a_233_297# VPB sky130_fd_pr__pfet_01v8_hvt ad=0.227 pd=1.55 as=0.265 ps=1.53 w=1 l=0.15
X8 VGND a_501_199# Y VNB sky130_fd_pr__nfet_01v8 ad=0.17575 pd=1.2 as=0.17225 ps=1.18 w=0.65 l=0.15
X9 a_683_361# C VPWR VPB sky130_fd_pr__pfet_01v8_hvt ad=0.1802 pd=1.21 as=0.227 ps=1.55 w=0.68 l=0.15
X10 a_501_199# A a_683_361# VPB sky130_fd_pr__pfet_01v8_hvt ad=0.1768 pd=1.88 as=0.1802 ps=1.21 w=0.68 l=0.15
X11 Y C a_315_47# VNB sky130_fd_pr__nfet_01v8 ad=0.17225 pd=1.18 as=0.10075 ps=0.96 w=0.65 l=0.15
.ends
