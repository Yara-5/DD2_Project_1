* dd2_g5__o21ai_stack_1: Y = (!A & !B) | !C
* Generated by synthesize.py; stages in signal order:
*   Y = !((A | B) & C)
.subckt dd2_g5__o21ai_stack_1 A B C VGND VNB VPB VPWR Y
XN1 Y A Y_d1 VNB sky130_fd_pr__nfet_01v8 w=1.3 l=0.15
XN2 Y B Y_d1 VNB sky130_fd_pr__nfet_01v8 w=1.3 l=0.15
XN3 Y_d1 C VGND VNB sky130_fd_pr__nfet_01v8 w=1.3 l=0.15
XP1 Y_u1 A VPWR VPB sky130_fd_pr__pfet_01v8_hvt w=2 l=0.15
XP2 Y B Y_u1 VPB sky130_fd_pr__pfet_01v8_hvt w=2 l=0.15
XP3 Y C VPWR VPB sky130_fd_pr__pfet_01v8_hvt w=1 l=0.15
.ends dd2_g5__o21ai_stack_1
