* NGSPICE file created from dd2_g5__o21ai_stack_1.ext - technology: sky130A

.subckt dd2_g5__o21ai_stack_1 A B C VGND VNB VPB VPWR Y
X0 a_63_47.t3 A.t0 VGND.t0 VNB.t3 sky130_fd_pr__nfet_01v8 ad=0.169 pd=1.82 as=0.08775 ps=0.92 w=0.65 l=0.15
X1 a_145_297.t0 B.t3 VPWR.t2 VPB.t0 sky130_fd_pr__pfet_01v8_hvt ad=0.135 pd=1.27 as=0.26 ps=2.52 w=1 l=0.15
X2 Y.t3 A.t2 a_145_297.t3 VPB.t3 sky130_fd_pr__pfet_01v8_hvt ad=0.26 pd=2.52 as=0.135 ps=1.27 w=1 l=0.15
X3 VGND.t2 A.t1 a_63_47.t2 VNB.t2 sky130_fd_pr__nfet_01v8 ad=0.08775 pd=0.92 as=0.08775 ps=0.92 w=0.65 l=0.15
X4 a_145_297.t2 A.t3 Y.t2 VPB.t2 sky130_fd_pr__pfet_01v8_hvt ad=0.135 pd=1.27 as=0.135 ps=1.27 w=1 l=0.15
X5 VGND.t1 B.t1 a_63_47.t0 VNB.t0 sky130_fd_pr__nfet_01v8 ad=0.08775 pd=0.92 as=0.169 ps=1.82 w=0.65 l=0.15
X6 Y.t0 C.t2 VPWR.t0 VPB.t4 sky130_fd_pr__pfet_01v8_hvt ad=0.135 pd=1.27 as=0.485 ps=1.97 w=1 l=0.15
X7 Y.t1 C.t1 a_63_47.t4 VNB.t4 sky130_fd_pr__nfet_01v8 ad=0.17875 pd=1.2 as=0.08775 ps=0.92 w=0.65 l=0.15
X8 VPWR.t1 B.t2 a_145_297.t1 VPB.t1 sky130_fd_pr__pfet_01v8_hvt ad=0.485 pd=1.97 as=0.135 ps=1.27 w=1 l=0.15
X9 a_63_47.t1 B.t0 VGND.t3 VNB.t1 sky130_fd_pr__nfet_01v8 ad=0.08775 pd=0.92 as=0.08775 ps=0.92 w=0.65 l=0.15
X10 a_63_47.t5 C.t0 Y.t4 VNB.t5 sky130_fd_pr__nfet_01v8 ad=0.08775 pd=0.92 as=0.17875 ps=1.2 w=0.65 l=0.15
R0 VGND.n4 VGND.n3 205.565
R1 VGND.n2 VGND.n1 199.739
R2 VGND.n7 VGND.n0 34.6358
R3 VGND.n1 VGND.t1 24.9236
R4 VGND.n1 VGND.t3 24.9236
R5 VGND.n3 VGND.t2 24.9236
R6 VGND.n3 VGND.t0 24.9236
R7 VGND.n4 VGND.n2 16.996
R8 VGND.n5 VGND.n0 9.3005
R9 VGND.n7 VGND.n6 9.3005
R10 VGND VGND.n7 6.77697
R11 VGND.n2 VGND.n0 0.376971
R12 VGND.n5 VGND.n4 0.164061
R13 VGND.n6 VGND.n5 0.120292
R14 VGND.n6 VGND 0.0239375
R15 Y.n1 Y.n0 585
R16 Y.n1 Y.t3 385.185
R17 Y.n3 Y.n2 185
R18 Y.n3 Y.n1 93.3518
R19 Y.n2 Y.t1 50.7697
R20 Y.n2 Y.t4 50.7697
R21 Y.n0 Y.t0 26.5955
R22 Y.n0 Y.t2 26.5955
R23 Y Y.n3 8.53383
R24 Y.n3 Y 4.87669
R25 VPWR.n2 VPWR.n1 617.601
R26 VPWR.n0 VPWR.t2 257.474
R27 VPWR.n1 VPWR.t0 164.495
R28 VPWR.n1 VPWR.t1 26.5955
R29 VPWR.n2 VPWR.n0 25.374
R30 VPWR.n4 VPWR.n0 15.8123
R31 VPWR.n4 VPWR.n3 9.3005
R32 VPWR VPWR.n4 6.77697
R33 VPWR.n3 VPWR.n2 1.19783
R34 VPWR.n3 VPWR 0.0239375
R35 A.n0 A.t2 212.081
R36 A.n1 A.t3 212.081
R37 A A.n2 155.103
R38 A.n0 A.t0 139.78
R39 A.n1 A.t1 139.78
R40 A.n2 A.n0 54.0429
R41 A.n2 A.n1 7.30353
R42 C.n1 C.t1 240.562
R43 C.n0 C.t2 212.081
R44 C C.n1 155.103
R45 C.n0 C.t0 139.78
R46 C.n1 C.n0 1.46111
R47 B.n1 B.t3 212.081
R48 B.n0 B.t2 212.081
R49 B B.n1 155.103
R50 B.n1 B.t1 139.78
R51 B.n0 B.t0 139.78
R52 B.n1 B.n0 61.346
R53 VPB.t1 VPB.t4 662.928
R54 VPB VPB.t0 301.87
R55 VPB.t2 VPB.t3 248.599
R56 VPB.t4 VPB.t2 248.599
R57 VPB.t0 VPB.t1 248.599
R58 VNB.t4 VNB.t5 1993.53
R59 VNB VNB.t0 1452.43
R60 VNB.t2 VNB.t3 1196.12
R61 VNB.t5 VNB.t2 1196.12
R62 VNB.t1 VNB.t4 1196.12
R63 VNB.t0 VNB.t1 1196.12
R64 a_63_47.n1 a_63_47.t3 335.647
R65 a_63_47.n2 a_63_47.t0 315.693
R66 a_63_47.n2 a_63_47.n1 260.935
R67 a_63_47.n1 a_63_47.n0 185
R68 a_63_47.n3 a_63_47.n2 185
R69 a_63_47.n0 a_63_47.t2 24.9236
R70 a_63_47.n0 a_63_47.t5 24.9236
R71 a_63_47.n3 a_63_47.t4 24.9236
R72 a_63_47.t1 a_63_47.n3 24.9236
R73 a_145_297.n1 a_145_297.n0 613.631
R74 a_145_297.n0 a_145_297.t3 26.5955
R75 a_145_297.n0 a_145_297.t2 26.5955
R76 a_145_297.t1 a_145_297.n1 26.5955
R77 a_145_297.n1 a_145_297.t0 26.5955
C0 VPWR VPB 0.12018f
C1 Y VPB 0.0189f
C2 VGND C 0.02089f
C3 C VPB 0.06083f
C4 B VPWR 0.04107f
C5 A VPWR 0.02273f
C6 VGND VPB 0.01469f
C7 B Y 0.0088f
C8 A Y 0.03598f
C9 B C 0.02126f
C10 A C 0.03922f
C11 B VGND 0.03185f
C12 A VGND 0.03124f
C13 B VPB 0.06528f
C14 A VPB 0.05682f
C15 VPWR Y 0.04255f
C16 VPWR C 0.01592f
C17 Y C 0.06047f
C18 VPWR VGND 0.04442f
C19 VGND Y 0.01499f
C20 VGND VNB 0.47741f
C21 Y VNB 0.04341f
C22 VPWR VNB 0.40265f
C23 A VNB 0.15501f
C24 C VNB 0.15381f
C25 B VNB 0.16349f
C26 VPB VNB 0.83278f
C27 a_145_297.t3 VNB 0.03896f
C28 a_145_297.t2 VNB 0.03896f
C29 a_145_297.n0 VNB 0.12679f
C30 a_145_297.t0 VNB 0.03856f
C31 a_145_297.n1 VNB 0.16787f
C32 a_145_297.t1 VNB 0.03856f
C33 a_63_47.t4 VNB 0.0405f
C34 a_63_47.t0 VNB 0.06072f
C35 a_63_47.t3 VNB 0.06496f
C36 a_63_47.t2 VNB 0.02567f
C37 a_63_47.t5 VNB 0.02875f
C38 a_63_47.n0 VNB 0.02445f
C39 a_63_47.n1 VNB 0.11647f
C40 a_63_47.n2 VNB 0.07212f
C41 a_63_47.n3 VNB 0.02445f
C42 a_63_47.t1 VNB 0.02539f
C43 VPB.t3 VNB 0.09122f
C44 VPB.t2 VNB 0.03649f
C45 VPB.t4 VNB 0.06689f
C46 VPB.t1 VNB 0.06689f
C47 VPB.t0 VNB 0.0404f
C48 B.n0 VNB 0.04598f
C49 B.n1 VNB 0.05137f
C50 C.n0 VNB 0.04096f
C51 C.n1 VNB 0.0707f
C52 A.n0 VNB 0.04476f
C53 A.n1 VNB 0.03156f
C54 A.n2 VNB 0.01869f
C55 VPWR.t2 VNB 0.05219f
C56 VPWR.n0 VNB 0.03106f
C57 VPWR.t0 VNB 0.07645f
C58 VPWR.t1 VNB 0.02734f
C59 VPWR.n1 VNB 0.06202f
C60 VPWR.n2 VNB 0.05737f
C61 VPWR.n3 VNB 0.22932f
C62 VPWR.n4 VNB 0.00323f
C63 Y.t3 VNB 0.08173f
C64 Y.t2 VNB 0.03454f
C65 Y.t0 VNB 0.03894f
C66 Y.n0 VNB 0.03071f
C67 Y.n1 VNB 0.08261f
C68 Y.t4 VNB 0.03685f
C69 Y.t1 VNB 0.0486f
C70 Y.n2 VNB 0.04066f
C71 Y.n3 VNB 0.03352f
C72 VGND.n0 VNB 0.00469f
C73 VGND.t3 VNB 0.01837f
C74 VGND.t1 VNB 0.01837f
C75 VGND.n1 VNB 0.0112f
C76 VGND.n2 VNB 0.02554f
C77 VGND.t0 VNB 0.01865f
C78 VGND.t2 VNB 0.01865f
C79 VGND.n3 VNB 0.01232f
C80 VGND.n4 VNB 0.19641f
C81 VGND.n5 VNB 0.0486f
C82 VGND.n6 VNB 0.01565f
C83 VGND.n7 VNB 0.00554f
.ends
