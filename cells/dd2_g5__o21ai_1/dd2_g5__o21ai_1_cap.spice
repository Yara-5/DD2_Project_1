* NGSPICE file created from dd2_g5__o21ai_1.ext - technology: sky130A

.subckt dd2_g5__o21ai_1 A1 A2 B1 VGND VNB VPB VPWR Y
X0 a_67_47# A2 VGND VNB sky130_fd_pr__nfet_01v8 ad=0.10725 pd=0.98 as=0.08775 ps=0.92 w=0.65 l=0.15
X1 VGND A1 a_67_47# VNB sky130_fd_pr__nfet_01v8 ad=0.08775 pd=0.92 as=0.169 ps=1.82 w=0.65 l=0.15
X2 VPWR B1 Y VPB sky130_fd_pr__pfet_01v8_hvt ad=0.182 pd=1.92 as=0.153 ps=1.33 w=0.7 l=0.15
X3 Y B1 a_67_47# VNB sky130_fd_pr__nfet_01v8 ad=0.169 pd=1.82 as=0.10725 ps=0.98 w=0.65 l=0.15
X4 Y A2 a_149_297# VPB sky130_fd_pr__pfet_01v8_hvt ad=0.153 pd=1.33 as=0.135 ps=1.27 w=1 l=0.15
X5 a_149_297# A1 VPWR VPB sky130_fd_pr__pfet_01v8_hvt ad=0.135 pd=1.27 as=0.26 ps=2.52 w=1 l=0.15
C0 a_149_297# Y 0.00437f
C1 B1 a_67_47# 0.00299f
C2 VGND A2 0.01548f
C3 B1 VPB 0.06153f
C4 A1 A2 0.03922f
C5 B1 A2 0.03636f
C6 VPWR Y 0.04018f
C7 VPB a_67_47# 0.0022f
C8 VPWR a_149_297# 0.01377f
C9 VGND Y 0.02259f
C10 A2 a_67_47# 0.01811f
C11 Y A1 0.00314f
C12 A2 VPB 0.02597f
C13 B1 Y 0.04816f
C14 VGND a_149_297# 0.00213f
C15 Y a_67_47# 0.01636f
C16 VPWR VGND 0.02807f
C17 VPWR A1 0.02256f
C18 Y VPB 0.02718f
C19 a_149_297# a_67_47# 0.00317f
C20 VPWR B1 0.01835f
C21 Y A2 0.00643f
C22 VGND A1 0.01554f
C23 a_149_297# A2 0
C24 VGND B1 0.01806f
C25 VPWR a_67_47# 0.00845f
C26 VPWR VPB 0.09583f
C27 VGND a_67_47# 0.06225f
C28 VPWR A2 0.0192f
C29 A1 a_67_47# 0.01938f
C30 VGND VPB 0.0146f
C31 A1 VPB 0.03097f
C32 VGND VNB 0.39524f
C33 Y VNB 0.12775f
C34 VPWR VNB 0.3152f
C35 VPB VNB 0.51617f
C36 a_67_47# VNB 0.09342f
.ends
