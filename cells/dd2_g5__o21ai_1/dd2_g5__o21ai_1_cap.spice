* NGSPICE file created from dd2_g5__o21ai_1.ext - technology: sky130A

.subckt dd2_g5__o21ai_1 A1 A2 B1 VGND VNB VPB VPWR Y
X0 a_67_47# A2 VGND VNB sky130_fd_pr__nfet_01v8 ad=0.10725 pd=0.98 as=0.08775 ps=0.92 w=0.65 l=0.15
X1 VGND A1 a_67_47# VNB sky130_fd_pr__nfet_01v8 ad=0.08775 pd=0.92 as=0.169 ps=1.82 w=0.65 l=0.15
X2 VPWR B1 Y VPB sky130_fd_pr__pfet_01v8_hvt ad=0.182 pd=1.92 as=0.153 ps=1.33 w=0.7 l=0.15
X3 Y B1 a_67_47# VNB sky130_fd_pr__nfet_01v8 ad=0.169 pd=1.82 as=0.10725 ps=0.98 w=0.65 l=0.15
X4 Y A2 a_149_297# VPB sky130_fd_pr__pfet_01v8_hvt ad=0.153 pd=1.33 as=0.135 ps=1.27 w=1 l=0.15
X5 a_149_297# A1 VPWR VPB sky130_fd_pr__pfet_01v8_hvt ad=0.135 pd=1.27 as=0.26 ps=2.52 w=1 l=0.15
C0 VGND A1 0.01554f
C1 a_149_297# A2 0
C2 VGND B1 0.01622f
C3 VPWR a_67_47# 0.00818f
C4 VPWR VPB 0.1083f
C5 VGND a_67_47# 0.06225f
C6 VPWR A2 0.02124f
C7 A1 a_67_47# 0.01938f
C8 VGND VPB 0.01453f
C9 A1 VPB 0.03097f
C10 a_149_297# Y 0.00682f
C11 B1 a_67_47# 0.00246f
C12 VGND A2 0.01548f
C13 B1 VPB 0.06153f
C14 A1 A2 0.03922f
C15 B1 A2 0.03636f
C16 VPWR Y 0.07618f
C17 VPB a_67_47# 0.0022f
C18 VPWR a_149_297# 0.01758f
C19 VGND Y 0.03463f
C20 A2 a_67_47# 0.01811f
C21 Y A1 0.00467f
C22 A2 VPB 0.02597f
C23 B1 Y 0.05663f
C24 VGND a_149_297# 0.00213f
C25 Y a_67_47# 0.02004f
C26 VPWR VGND 0.02765f
C27 VPWR A1 0.02957f
C28 Y VPB 0.02356f
C29 a_149_297# a_67_47# 0.00317f
C30 VPWR B1 0.02107f
C31 Y A2 0.01007f
C32 VGND VNB 0.39109f
C33 Y VNB 0.11851f
C34 VPWR VNB 0.34399f
C35 VPB VNB 0.51617f
C36 a_67_47# VNB 0.09342f
.ends
