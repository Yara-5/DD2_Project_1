* NGSPICE file created from dd2_g5__o21ai_1.ext - technology: sky130A

.subckt dd2_g5__o21ai_1 A1 A2 B1 VGND VNB VPB VPWR Y
X0 a_67_47.t2 A2.t0 VGND.t0 VNB.t2 sky130_fd_pr__nfet_01v8 ad=0.10725 pd=0.98 as=0.08775 ps=0.92 w=0.65 l=0.15
X1 VGND.t1 A1.t0 a_67_47.t0 VNB.t0 sky130_fd_pr__nfet_01v8 ad=0.08775 pd=0.92 as=0.169 ps=1.82 w=0.65 l=0.15
X2 VPWR.t0 B1.t1 Y.t2 VPB.t1 sky130_fd_pr__pfet_01v8_hvt ad=0.182 pd=1.92 as=0.153 ps=1.33 w=0.7 l=0.15
X3 Y.t1 B1.t0 a_67_47.t1 VNB.t1 sky130_fd_pr__nfet_01v8 ad=0.169 pd=1.82 as=0.10725 ps=0.98 w=0.65 l=0.15
X4 Y.t0 A2.t1 a_149_297.t1 VPB.t2 sky130_fd_pr__pfet_01v8_hvt ad=0.153 pd=1.33 as=0.135 ps=1.27 w=1 l=0.15
X5 a_149_297.t0 A1.t1 VPWR.t1 VPB.t0 sky130_fd_pr__pfet_01v8_hvt ad=0.135 pd=1.27 as=0.26 ps=2.52 w=1 l=0.15
R0 VGND.n1 VGND.n0 204.743
R1 VGND.n0 VGND.t0 24.9236
R2 VGND.n0 VGND.t1 24.9236
R3 VGND VGND.n1 13.3236
R4 VGND.n1 VGND 1.05308
R5 Y.n1 Y.n0 415.699
R6 Y.t1 Y.n1 268.077
R7 Y Y.t1 265.829
R8 Y.n0 Y.t2 46.4362
R9 Y.n0 Y.t0 40.0168
R10 Y.n2 Y 2.90959
R11 Y.n2 Y.n1 2.86366
R12 Y Y.n2 2.52682
R13 VPWR.n1 VPWR.t0 371.332
R14 VPWR.n0 VPWR.t1 257.474
R15 VPWR.n1 VPWR.n0 24.7435
R16 VPWR.n3 VPWR.n0 17.3181
R17 VPWR.n3 VPWR.n2 9.3005
R18 VPWR VPWR.n3 6.77697
R19 VPWR.n2 VPWR.n1 0.322546
R20 VPWR.n2 VPWR 0.0239375
R21 B1.n0 B1.t1 289.736
R22 B1.n0 B1.t0 169.237
R23 B1 B1.n0 155.103
R24 A2.n0 A2.t1 241.536
R25 A2.n0 A2.t0 169.237
R26 A2 A2.n0 155.103
R27 A1.n0 A1.t1 241.536
R28 A1.n0 A1.t0 169.237
R29 A1 A1.n0 155.103
R30 VPB VPB.t0 313.707
R31 VPB.t2 VPB.t1 284.113
R32 VPB.t0 VPB.t2 248.599
R33 VNB VNB.t0 1509.39
R34 VNB.t2 VNB.t1 1366.99
R35 VNB.t0 VNB.t2 1196.12
R36 a_67_47.t0 a_67_47.n0 460.43
R37 a_67_47.n0 a_67_47.t1 30.462
R38 a_67_47.n0 a_67_47.t2 30.462
R39 a_149_297.t0 a_149_297.t1 53.1905
C0 A2 Y 0.01007f
C1 A1 Y 0.00467f
C2 Y B1 0.05663f
C3 VPWR VGND 0.02765f
C4 VPB A2 0.02597f
C5 A1 VPB 0.03097f
C6 VPB B1 0.06153f
C7 VPB Y 0.02356f
C8 VPWR A2 0.02124f
C9 A1 VPWR 0.02957f
C10 VPWR B1 0.02107f
C11 VPWR Y 0.07618f
C12 A2 VGND 0.01548f
C13 A1 VGND 0.01554f
C14 B1 VGND 0.01622f
C15 Y VGND 0.03463f
C16 VPB VPWR 0.1083f
C17 A1 A2 0.03922f
C18 A2 B1 0.03636f
C19 VPB VGND 0.01453f
C20 VGND VNB 0.45385f
C21 Y VNB 0.09701f
C22 VPWR VNB 0.31572f
C23 B1 VNB 0.11339f
C24 A2 VNB 0.07553f
C25 A1 VNB 0.11055f
C26 VPB VNB 0.57546f
C27 a_149_297.t1 VNB 0.04191f
C28 a_149_297.t0 VNB 0.03749f
C29 a_67_47.t1 VNB 0.03456f
C30 a_67_47.t2 VNB 0.03133f
C31 a_67_47.n0 VNB 0.05211f
C32 a_67_47.t0 VNB 0.07628f
C33 VPB.t1 VNB 0.11559f
C34 VPB.t2 VNB 0.04484f
C35 VPB.t0 VNB 0.04733f
C36 A1.n0 VNB 0.04537f
C37 A2.n0 VNB 0.05426f
C38 B1.n0 VNB 0.06801f
C39 VPWR.t1 VNB 0.05859f
C40 VPWR.n0 VNB 0.03425f
C41 VPWR.t0 VNB 0.05424f
C42 VPWR.n1 VNB 0.10381f
C43 VPWR.n2 VNB 0.09031f
C44 VPWR.n3 VNB 0.00372f
C45 Y.t2 VNB 0.04216f
C46 Y.t0 VNB 0.04129f
C47 Y.n0 VNB 0.05756f
C48 Y.n1 VNB 0.08435f
C49 Y.t1 VNB 0.05312f
C50 Y.n2 VNB 0.00972f
C51 VGND.t0 VNB 0.02409f
C52 VGND.t1 VNB 0.0209f
C53 VGND.n0 VNB 0.01061f
C54 VGND.n1 VNB 0.03478f
.ends
