* NGSPICE file created from dd2_g5__mux2_1.ext - technology: sky130A

.subckt dd2_g5__mux2_1 A0 A1 S VGND VNB VPB VPWR X
X0 X.t3 a_127_47.t3 a_233_297.t1 VPB.t2 sky130_fd_pr__pfet_01v8_hvt ad=0.155 pd=1.31 as=0.26 ps=2.52 w=1 l=0.15
X1 a_501_199.t2 S.t0 VGND.t3 VNB.t5 sky130_fd_pr__nfet_01v8 ad=0.17225 pd=1.18 as=0.17875 ps=1.2 w=0.65 l=0.15
X2 a_127_47.t0 A1.t1 VPWR.t0 VPB.t0 sky130_fd_pr__pfet_01v8_hvt ad=0.26 pd=2.52 as=0.26 ps=2.52 w=1 l=0.15
X3 VGND.t2 A0.t0 a_501_199.t0 VNB.t3 sky130_fd_pr__nfet_01v8 ad=0.169 pd=1.82 as=0.17225 ps=1.18 w=0.65 l=0.15
X4 a_683_297.t1 S.t2 VPWR.t2 VPB.t5 sky130_fd_pr__pfet_01v8_hvt ad=0.265 pd=1.53 as=0.275 ps=1.55 w=1 l=0.15
X5 a_501_199.t1 A0.t1 a_683_297.t0 VPB.t3 sky130_fd_pr__pfet_01v8_hvt ad=0.26 pd=2.52 as=0.265 ps=1.53 w=1 l=0.15
X6 a_233_297.t2 S.t3 X.t0 VPB.t4 sky130_fd_pr__pfet_01v8_hvt ad=0.265 pd=1.53 as=0.155 ps=1.31 w=1 l=0.15
X7 a_127_47.t1 A1.t0 VGND.t0 VNB.t0 sky130_fd_pr__nfet_01v8 ad=0.169 pd=1.82 as=0.169 ps=1.82 w=0.65 l=0.15
X8 a_315_47.t0 a_127_47.t2 VGND.t4 VNB.t2 sky130_fd_pr__nfet_01v8 ad=0.10075 pd=0.96 as=0.169 ps=1.82 w=0.65 l=0.15
X9 VPWR.t1 a_501_199.t4 a_233_297.t0 VPB.t1 sky130_fd_pr__pfet_01v8_hvt ad=0.275 pd=1.55 as=0.265 ps=1.53 w=1 l=0.15
X10 VGND.t1 a_501_199.t3 X.t1 VNB.t1 sky130_fd_pr__nfet_01v8 ad=0.17875 pd=1.2 as=0.17225 ps=1.18 w=0.65 l=0.15
X11 X.t2 S.t1 a_315_47.t1 VNB.t4 sky130_fd_pr__nfet_01v8 ad=0.17225 pd=1.18 as=0.10075 ps=0.96 w=0.65 l=0.15
R0 VGND.n5 VGND.t2 289.209
R1 VGND.n14 VGND.t0 282.817
R2 VGND.n10 VGND.t4 282.817
R3 VGND.n4 VGND.n3 199.739
R4 VGND.n3 VGND.t1 50.7697
R5 VGND.n3 VGND.t3 50.7697
R6 VGND.n9 VGND.n8 34.6358
R7 VGND.n8 VGND.n2 34.6358
R8 VGND.n10 VGND.n0 32.7534
R9 VGND.n4 VGND.n2 22.2123
R10 VGND.n14 VGND.n0 13.177
R11 VGND.n10 VGND.n9 11.6711
R12 VGND.n12 VGND.n0 9.3005
R13 VGND.n11 VGND.n10 9.3005
R14 VGND.n9 VGND.n1 9.3005
R15 VGND.n8 VGND.n7 9.3005
R16 VGND.n6 VGND.n2 9.3005
R17 VGND.n14 VGND.n13 9.3005
R18 VGND.n5 VGND.n4 6.93613
R19 VGND.n14 VGND 5.53564
R20 VGND VGND.n14 3.10353
R21 VGND.n6 VGND.n5 0.280421
R22 VGND.n13 VGND.n12 0.120292
R23 VGND.n12 VGND.n11 0.120292
R24 VGND.n11 VGND.n1 0.120292
R25 VGND.n7 VGND.n1 0.120292
R26 VGND.n7 VGND.n6 0.120292
R27 VGND.n13 VGND 0.0239375
R28 X X.n1 686.611
R29 X X.n0 191.024
R30 X.n0 X.t1 48.9236
R31 X.n0 X.t2 48.9236
R32 X.n1 X.t0 30.5355
R33 X.n1 X.t3 30.5355
R34 VPWR VPWR.t0 875.817
R35 VPWR.n2 VPWR.n1 614.205
R36 VPWR.n1 VPWR.t1 54.1755
R37 VPWR.n1 VPWR.t2 54.1755
R38 VPWR.n2 VPWR.n0 33.1997
R39 VPWR.n4 VPWR.n3 9.3005
R40 VPWR.n4 VPWR.n0 9.03579
R41 VPWR VPWR.n4 6.77697
R42 VPWR.n0 VPWR 0.376971
R43 VPWR.n3 VPWR.n2 0.148621
R44 VPWR.n3 VPWR 0.0239375
R45 A0.n0 A0.t1 241.536
R46 A0.n0 A0.t0 169.237
R47 A0 A0.n0 155.103
R48 S.n2 S.n0 285.497
R49 S.n1 S.t3 241.536
R50 S.n0 S.t2 241.536
R51 S.n1 S.t1 169.237
R52 S.n0 S.t0 169.237
R53 S.n2 S.n1 152
R54 S S.n2 4.0965
R55 A1.n0 A1.t1 241.536
R56 A1.n0 A1.t0 169.237
R57 A1 A1.n0 155.103
R58 VPB.t0 VPB.t2 556.386
R59 VPB.t1 VPB.t5 414.33
R60 VPB.t5 VPB.t3 402.493
R61 VPB.t4 VPB.t1 402.493
R62 VPB.t2 VPB.t4 272.274
R63 VPB VPB.t0 248.599
R64 VNB.t0 VNB.t2 2677.02
R65 VNB.t1 VNB.t5 1993.53
R66 VNB.t5 VNB.t3 1936.57
R67 VNB.t4 VNB.t1 1936.57
R68 VNB.t2 VNB.t4 1310.03
R69 VNB VNB.t0 1196.12
R70 a_315_47.t0 a_315_47.t1 57.2313
R71 a_683_297.t0 a_683_297.t1 104.41
R72 a_233_297.n0 a_233_297.t1 1515.03
R73 a_233_297.t0 a_233_297.n0 52.2055
R74 a_233_297.n0 a_233_297.t2 52.2055
R75 a_501_199.t1 a_501_199.n2 927.396
R76 a_501_199.n2 a_501_199.n0 248.376
R77 a_501_199.n0 a_501_199.t4 241.536
R78 a_501_199.n2 a_501_199.n1 190.69
R79 a_501_199.n0 a_501_199.t3 169.237
R80 a_501_199.n1 a_501_199.t0 48.9236
R81 a_501_199.n1 a_501_199.t2 48.9236
R82 a_127_47.t0 a_127_47.n1 850.864
R83 a_127_47.n0 a_127_47.t3 229.754
R84 a_127_47.n1 a_127_47.t1 229.536
R85 a_127_47.n1 a_127_47.n0 165.577
R86 a_127_47.n0 a_127_47.t2 157.453
C0 A1 VGND 0.02269f
C1 S A0 0.01429f
C2 X A0 0
C3 S VPB 0.0721f
C4 S VGND 0.03647f
C5 X VPB 0.00886f
C6 X VGND 0.05317f
C7 VPWR A0 0.01419f
C8 VPWR VPB 0.14019f
C9 X S 0.06038f
C10 VPWR VGND 0.05802f
C11 VPWR A1 0.02065f
C12 VPWR S 0.06071f
C13 A0 VPB 0.03362f
C14 VPWR X 0.01078f
C15 VGND A0 0.02172f
C16 VGND VPB 0.01862f
C17 A1 VPB 0.03546f
C18 VGND VNB 0.5878f
C19 X VNB 0.09017f
C20 VPWR VNB 0.47827f
C21 A0 VNB 0.11494f
C22 S VNB 0.14147f
C23 A1 VNB 0.11591f
C24 VPB VNB 1.00495f
C25 a_127_47.t1 VNB 0.04953f
C26 a_127_47.n0 VNB 0.04895f
C27 a_127_47.n1 VNB 0.09046f
C28 a_127_47.t0 VNB 0.07113f
C29 a_501_199.n0 VNB 0.05241f
C30 a_501_199.t0 VNB 0.0362f
C31 a_501_199.t2 VNB 0.03997f
C32 a_501_199.n1 VNB 0.04322f
C33 a_501_199.n2 VNB 0.13318f
C34 a_501_199.t1 VNB 0.08354f
C35 a_233_297.t2 VNB 0.05062f
C36 a_233_297.t1 VNB 0.08057f
C37 a_233_297.n0 VNB 0.07826f
C38 a_233_297.t0 VNB 0.04409f
C39 a_683_297.t1 VNB 0.047f
C40 a_683_297.t0 VNB 0.04179f
C41 a_315_47.t1 VNB 0.02821f
C42 a_315_47.t0 VNB 0.02164f
C43 VPB.t3 VNB 0.09416f
C44 VPB.t5 VNB 0.05853f
C45 VPB.t1 VNB 0.05853f
C46 VPB.t4 VNB 0.04835f
C47 VPB.t2 VNB 0.05938f
C48 VPB.t0 VNB 0.05768f
C49 A1.n0 VNB 0.03878f
C50 S.n0 VNB 0.08249f
C51 S.n1 VNB 0.05121f
C52 S.n2 VNB 0.11948f
C53 A0.n0 VNB 0.04099f
C54 VPWR.t0 VNB 0.0493f
C55 VPWR.n0 VNB 0.00752f
C56 VPWR.t2 VNB 0.04311f
C57 VPWR.t1 VNB 0.03658f
C58 VPWR.n1 VNB 0.03578f
C59 VPWR.n2 VNB 0.33951f
C60 VPWR.n3 VNB 0.0259f
C61 VPWR.n4 VNB 0.00228f
C62 X.t1 VNB 0.03292f
C63 X.t2 VNB 0.03763f
C64 X.n0 VNB 0.03863f
C65 X.t0 VNB 0.0428f
C66 X.t3 VNB 0.03375f
C67 X.n1 VNB 0.04057f
C68 VGND.n0 VNB 0.00466f
C69 VGND.t0 VNB 0.02792f
C70 VGND.n1 VNB 0.01983f
C71 VGND.n2 VNB 0.00576f
C72 VGND.t2 VNB 0.02928f
C73 VGND.t3 VNB 0.02652f
C74 VGND.t1 VNB 0.0218f
C75 VGND.n3 VNB 0.01665f
C76 VGND.n4 VNB 0.02169f
C77 VGND.n5 VNB 0.07105f
C78 VGND.n6 VNB 0.05828f
C79 VGND.n7 VNB 0.01983f
C80 VGND.n8 VNB 0.00702f
C81 VGND.n9 VNB 0.00469f
C82 VGND.t4 VNB 0.02591f
C83 VGND.n10 VNB 0.02199f
C84 VGND.n11 VNB 0.01983f
C85 VGND.n12 VNB 0.01983f
C86 VGND.n13 VNB 0.01185f
C87 VGND.n14 VNB 0.01956f
.ends
