* dd2_g5__mux2_1: X = (A0 | S) & (A1 | !S)
* Generated by synthesize.py; stages in signal order:
*   A1_N = !(A1)
*   n1 = !(A0 | S)
*   X = !(n1 | (A1_N & S))
.subckt dd2_g5__mux2_1 A0 A1 S VGND VNB VPB VPWR X
XN1 A1_N A1 VGND VNB sky130_fd_pr__nfet_01v8 w=0.65 l=0.15
XP1 A1_N A1 VPWR VPB sky130_fd_pr__pfet_01v8_hvt w=1 l=0.15
XN2 n1 A0 VGND VNB sky130_fd_pr__nfet_01v8 w=0.65 l=0.15
XN3 n1 S VGND VNB sky130_fd_pr__nfet_01v8 w=0.65 l=0.15
XP2 n1_u1 A0 VPWR VPB sky130_fd_pr__pfet_01v8_hvt w=1 l=0.15
XP3 n1 S n1_u1 VPB sky130_fd_pr__pfet_01v8_hvt w=1 l=0.15
XN4 X n1 VGND VNB sky130_fd_pr__nfet_01v8 w=0.65 l=0.15
XN5 X A1_N X_d1 VNB sky130_fd_pr__nfet_01v8 w=0.65 l=0.15
XN6 X_d1 S VGND VNB sky130_fd_pr__nfet_01v8 w=0.65 l=0.15
XP4 X_u1 n1 VPWR VPB sky130_fd_pr__pfet_01v8_hvt w=1 l=0.15
XP5 X A1_N X_u1 VPB sky130_fd_pr__pfet_01v8_hvt w=1 l=0.15
XP6 X S X_u1 VPB sky130_fd_pr__pfet_01v8_hvt w=1 l=0.15
.ends dd2_g5__mux2_1
