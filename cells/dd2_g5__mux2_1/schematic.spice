* Intended schematic from supplied transistor connections.
* SKY130 model files use um-scale W/L convention; load the course model setup.
.subckt dd2_g5__mux2_1 A0 A1 S VGND VNB VPB VPWR X
XN1 A1_N A1 VGND VNB sky130_fd_pr__nfet_01v8 w=0.65 l=0.15
XP1 VPWR A1 A1_N VPB sky130_fd_pr__pfet_01v8_hvt w=1 l=0.15
XN2 n1 A0 VGND VNB sky130_fd_pr__nfet_01v8 w=0.65 l=0.15
XN3 n1 S VGND VNB sky130_fd_pr__nfet_01v8 w=0.65 l=0.15
XP2 n1_u1 A0 n1 VPB sky130_fd_pr__pfet_01v8_hvt w=1 l=0.15
XP3 VPWR S n1_u1 VPB sky130_fd_pr__pfet_01v8_hvt w=1 l=0.15
XN4 X n1 VGND VNB sky130_fd_pr__nfet_01v8 w=0.65 l=0.15
XN5 X_d1 A1_N VGND VNB sky130_fd_pr__nfet_01v8 w=0.65 l=0.15
XN6 X S X_d1 VNB sky130_fd_pr__nfet_01v8 w=0.65 l=0.15
XP4 VPWR n1 X_u1 VPB sky130_fd_pr__pfet_01v8_hvt w=1 l=0.15
XP5 X_u1 A1_N X VPB sky130_fd_pr__pfet_01v8_hvt w=1 l=0.15
XP6 X_u1 S X VPB sky130_fd_pr__pfet_01v8_hvt w=1 l=0.15
.ends dd2_g5__mux2_1
