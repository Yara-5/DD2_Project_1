* NGSPICE file created from dd2_g5__mux2_1.ext - technology: sky130A

.subckt dd2_g5__mux2_1 A0 A1 S VGND VNB VPB VPWR X
X0 X a_127_47# a_233_297# VPB sky130_fd_pr__pfet_01v8_hvt ad=0.155 pd=1.31 as=0.26 ps=2.52 w=1 l=0.15
X1 a_501_199# S VGND VNB sky130_fd_pr__nfet_01v8 ad=0.17225 pd=1.18 as=0.17875 ps=1.2 w=0.65 l=0.15
X2 a_127_47# A1 VPWR VPB sky130_fd_pr__pfet_01v8_hvt ad=0.26 pd=2.52 as=0.26 ps=2.52 w=1 l=0.15
X3 VGND A0 a_501_199# VNB sky130_fd_pr__nfet_01v8 ad=0.169 pd=1.82 as=0.17225 ps=1.18 w=0.65 l=0.15
X4 a_683_297# S VPWR VPB sky130_fd_pr__pfet_01v8_hvt ad=0.265 pd=1.53 as=0.275 ps=1.55 w=1 l=0.15
X5 a_501_199# A0 a_683_297# VPB sky130_fd_pr__pfet_01v8_hvt ad=0.26 pd=2.52 as=0.265 ps=1.53 w=1 l=0.15
X6 a_233_297# S X VPB sky130_fd_pr__pfet_01v8_hvt ad=0.265 pd=1.53 as=0.155 ps=1.31 w=1 l=0.15
X7 a_127_47# A1 VGND VNB sky130_fd_pr__nfet_01v8 ad=0.169 pd=1.82 as=0.169 ps=1.82 w=0.65 l=0.15
X8 a_315_47# a_127_47# VGND VNB sky130_fd_pr__nfet_01v8 ad=0.10075 pd=0.96 as=0.169 ps=1.82 w=0.65 l=0.15
X9 VPWR a_501_199# a_233_297# VPB sky130_fd_pr__pfet_01v8_hvt ad=0.275 pd=1.55 as=0.265 ps=1.53 w=1 l=0.15
X10 VGND a_501_199# X VNB sky130_fd_pr__nfet_01v8 ad=0.17875 pd=1.2 as=0.17225 ps=1.18 w=0.65 l=0.15
X11 X S a_315_47# VNB sky130_fd_pr__nfet_01v8 ad=0.17225 pd=1.18 as=0.10075 ps=0.96 w=0.65 l=0.15
C0 a_233_297# S 0.03812f
C1 a_683_297# A0 0
C2 a_501_199# A0 0.04885f
C3 VPB A1 0.03542f
C4 X a_233_297# 0.02559f
C5 VPB S 0.0721f
C6 a_233_297# VGND 0.00734f
C7 VPB X 0.00869f
C8 a_683_297# a_501_199# 0.02419f
C9 a_233_297# a_127_47# 0.04436f
C10 VPB VGND 0.01661f
C11 S A0 0.01429f
C12 X A0 0
C13 VPB a_127_47# 0.05616f
C14 VPWR a_233_297# 0.11461f
C15 A1 a_501_199# 0
C16 a_501_199# a_315_47# 0
C17 a_683_297# S 0
C18 VGND A0 0.02546f
C19 a_501_199# S 0.13495f
C20 VPB VPWR 0.14312f
C21 X a_683_297# 0
C22 X a_501_199# 0.01613f
C23 a_127_47# A0 0
C24 a_683_297# VGND 0.00357f
C25 a_501_199# VGND 0.1299f
C26 S a_315_47# 0
C27 VPWR A0 0.01352f
C28 a_683_297# a_127_47# 0
C29 a_127_47# a_501_199# 0
C30 X a_315_47# 0.00948f
C31 X S 0.06038f
C32 A1 VGND 0.02653f
C33 VGND a_315_47# 0.00837f
C34 VPWR a_683_297# 0.02551f
C35 VPWR a_501_199# 0.0678f
C36 VPB a_233_297# 0.01001f
C37 S VGND 0.03602f
C38 A1 a_127_47# 0.0485f
C39 a_127_47# a_315_47# 0
C40 X VGND 0.05327f
C41 a_127_47# S 0.025f
C42 A1 VPWR 0.02324f
C43 X a_127_47# 0.0509f
C44 VPWR a_315_47# 0
C45 VPWR S 0.06526f
C46 VPB A0 0.03362f
C47 a_127_47# VGND 0.0695f
C48 X VPWR 0.01053f
C49 a_233_297# a_501_199# 0.00488f
C50 VPWR VGND 0.05695f
C51 VPB a_501_199# 0.0503f
C52 VPWR a_127_47# 0.0809f
C53 A1 a_233_297# 0
C54 a_233_297# a_315_47# 0
C55 VGND VNB 0.73566f
C56 X VNB 0.06281f
C57 VPWR VNB 0.64002f
C58 VPB VNB 0.95915f
C59 a_315_47# VNB 0.02541f
C60 a_233_297# VNB 0.17476f
.ends
