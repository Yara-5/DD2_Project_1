* NGSPICE file created from dd2_g5__mux2_1.ext - technology: sky130A

.subckt dd2_g5__mux2_1 A0 A1 S VGND VNB VPB VPWR X
X0 X a_127_47# a_233_297# VPB sky130_fd_pr__pfet_01v8_hvt ad=0.155 pd=1.31 as=0.26 ps=2.52 w=1 l=0.15
X1 a_501_199# S VGND VNB sky130_fd_pr__nfet_01v8 ad=0.17225 pd=1.18 as=0.17875 ps=1.2 w=0.65 l=0.15
X2 a_127_47# A1 VPWR VPB sky130_fd_pr__pfet_01v8_hvt ad=0.26 pd=2.52 as=0.26 ps=2.52 w=1 l=0.15
X3 VGND A0 a_501_199# VNB sky130_fd_pr__nfet_01v8 ad=0.169 pd=1.82 as=0.17225 ps=1.18 w=0.65 l=0.15
X4 a_683_297# S VPWR VPB sky130_fd_pr__pfet_01v8_hvt ad=0.265 pd=1.53 as=0.275 ps=1.55 w=1 l=0.15
X5 a_501_199# A0 a_683_297# VPB sky130_fd_pr__pfet_01v8_hvt ad=0.26 pd=2.52 as=0.265 ps=1.53 w=1 l=0.15
X6 a_233_297# S X VPB sky130_fd_pr__pfet_01v8_hvt ad=0.265 pd=1.53 as=0.155 ps=1.31 w=1 l=0.15
X7 a_127_47# A1 VGND VNB sky130_fd_pr__nfet_01v8 ad=0.169 pd=1.82 as=0.169 ps=1.82 w=0.65 l=0.15
X8 a_315_47# a_127_47# VGND VNB sky130_fd_pr__nfet_01v8 ad=0.10075 pd=0.96 as=0.169 ps=1.82 w=0.65 l=0.15
X9 VPWR a_501_199# a_233_297# VPB sky130_fd_pr__pfet_01v8_hvt ad=0.275 pd=1.55 as=0.265 ps=1.53 w=1 l=0.15
X10 VGND a_501_199# X VNB sky130_fd_pr__nfet_01v8 ad=0.17875 pd=1.2 as=0.17225 ps=1.18 w=0.65 l=0.15
X11 X S a_315_47# VNB sky130_fd_pr__nfet_01v8 ad=0.17225 pd=1.18 as=0.10075 ps=0.96 w=0.65 l=0.15
C0 a_683_297# VGND 0.00358f
C1 a_501_199# VGND 0.10255f
C2 S a_315_47# 0
C3 VPWR A0 0.01419f
C4 X a_315_47# 0.00948f
C5 X S 0.06038f
C6 A1 VGND 0.02269f
C7 VGND a_315_47# 0.00826f
C8 VPWR a_683_297# 0.02161f
C9 VPWR a_501_199# 0.04441f
C10 VPB a_233_297# 0.01035f
C11 S VGND 0.03647f
C12 A1 a_127_47# 0.03958f
C13 a_127_47# a_315_47# 0
C14 X VGND 0.05317f
C15 a_127_47# S 0.02482f
C16 A1 VPWR 0.02065f
C17 X a_127_47# 0.0503f
C18 VPWR a_315_47# 0
C19 VPWR S 0.06071f
C20 VPB A0 0.03362f
C21 a_127_47# VGND 0.05839f
C22 X VPWR 0.01078f
C23 a_233_297# a_501_199# 0.00195f
C24 VPWR VGND 0.05802f
C25 VPB a_501_199# 0.04601f
C26 VPWR a_127_47# 0.03314f
C27 A1 a_233_297# 0
C28 a_233_297# a_315_47# 0
C29 a_233_297# S 0.03202f
C30 a_683_297# A0 0
C31 a_501_199# A0 0.042f
C32 VPB A1 0.03546f
C33 X a_233_297# 0.01987f
C34 VPB S 0.0721f
C35 a_233_297# VGND 0.0077f
C36 VPB X 0.00886f
C37 a_683_297# a_501_199# 0.01615f
C38 a_233_297# a_127_47# 0.0198f
C39 S A0 0.01429f
C40 VPB VGND 0.01862f
C41 X A0 0
C42 VPB a_127_47# 0.05723f
C43 VPWR a_233_297# 0.0999f
C44 a_501_199# a_315_47# 0
C45 a_683_297# S 0
C46 VGND A0 0.02172f
C47 a_501_199# S 0.13134f
C48 VPB VPWR 0.14019f
C49 X a_683_297# 0
C50 X a_501_199# 0.01596f
C51 VGND VNB 0.70975f
C52 X VNB 0.07201f
C53 VPWR VNB 0.61706f
C54 VPB VNB 0.95915f
C55 a_315_47# VNB 0.02541f
C56 a_233_297# VNB 0.17817f
.ends
