* dd2_g5__a22oi_stack_1: Y = (!A | !B) & (!C | !D)
* Generated by synthesize.py; stages in signal order:
*   Y = !((A & B) | (C & D))
.subckt dd2_g5__a22oi_stack_1 A B C D VGND VNB VPB VPWR Y
XN1 Y A Y_d1 VNB sky130_fd_pr__nfet_01v8 w=1.3 l=0.15
XN2 Y_d1 B VGND VNB sky130_fd_pr__nfet_01v8 w=1.3 l=0.15
XN3 Y C Y_d2 VNB sky130_fd_pr__nfet_01v8 w=1.3 l=0.15
XN4 Y_d2 D VGND VNB sky130_fd_pr__nfet_01v8 w=1.3 l=0.15
XP1 Y_u1 A VPWR VPB sky130_fd_pr__pfet_01v8_hvt w=2 l=0.15
XP2 Y_u1 B VPWR VPB sky130_fd_pr__pfet_01v8_hvt w=2 l=0.15
XP3 Y C Y_u1 VPB sky130_fd_pr__pfet_01v8_hvt w=2 l=0.15
XP4 Y D Y_u1 VPB sky130_fd_pr__pfet_01v8_hvt w=2 l=0.15
.ends dd2_g5__a22oi_stack_1
