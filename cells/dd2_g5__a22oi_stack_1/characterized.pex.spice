* NGSPICE file created from dd2_g5__a22oi_stack_1.ext - technology: sky130A

.subckt dd2_g5__a22oi_stack_1 A B C D VGND VNB VPB VPWR Y
X0 Y.t7 C.t1 a_491_47.t2 VNB.t6 sky130_fd_pr__nfet_01v8 ad=0.08775 pd=0.92 as=0.169 ps=1.82 w=0.65 l=0.15
X1 VGND.t2 D.t1 a_491_47.t0 VNB.t4 sky130_fd_pr__nfet_01v8 ad=0.08775 pd=0.92 as=0.08775 ps=0.92 w=0.65 l=0.15
X2 a_125_297.t5 D.t2 Y.t0 VPB.t5 sky130_fd_pr__pfet_01v8_hvt ad=0.26 pd=2.52 as=0.135 ps=1.27 w=1 l=0.15
X3 a_491_47.t3 C.t0 Y.t2 VNB.t7 sky130_fd_pr__nfet_01v8 ad=0.08775 pd=0.92 as=0.08775 ps=0.92 w=0.65 l=0.15
X4 a_491_47.t1 D.t0 VGND.t0 VNB.t5 sky130_fd_pr__nfet_01v8 ad=0.169 pd=1.82 as=0.08775 ps=0.92 w=0.65 l=0.15
X5 Y.t6 B.t1 a_43_47.t0 VNB.t0 sky130_fd_pr__nfet_01v8 ad=0.08775 pd=0.92 as=0.08775 ps=0.92 w=0.65 l=0.15
X6 VPWR.t0 B.t2 a_125_297.t1 VPB.t1 sky130_fd_pr__pfet_01v8_hvt ad=0.26 pd=2.52 as=0.135 ps=1.27 w=1 l=0.15
X7 VGND.t3 A.t1 a_43_47.t2 VNB.t2 sky130_fd_pr__nfet_01v8 ad=0.10075 pd=0.96 as=0.169 ps=1.82 w=0.65 l=0.15
X8 a_125_297.t0 B.t3 VPWR.t1 VPB.t0 sky130_fd_pr__pfet_01v8_hvt ad=0.135 pd=1.27 as=0.135 ps=1.27 w=1 l=0.15
X9 Y.t1 D.t3 a_125_297.t4 VPB.t4 sky130_fd_pr__pfet_01v8_hvt ad=0.135 pd=1.27 as=0.135 ps=1.27 w=1 l=0.15
X10 VPWR.t3 A.t2 a_125_297.t3 VPB.t3 sky130_fd_pr__pfet_01v8_hvt ad=0.135 pd=1.27 as=0.155 ps=1.31 w=1 l=0.15
X11 a_43_47.t3 A.t0 VGND.t1 VNB.t3 sky130_fd_pr__nfet_01v8 ad=0.08775 pd=0.92 as=0.10075 ps=0.96 w=0.65 l=0.15
X12 a_125_297.t2 A.t3 VPWR.t2 VPB.t2 sky130_fd_pr__pfet_01v8_hvt ad=0.155 pd=1.31 as=0.26 ps=2.52 w=1 l=0.15
X13 a_125_297.t7 C.t2 Y.t3 VPB.t7 sky130_fd_pr__pfet_01v8_hvt ad=0.135 pd=1.27 as=0.135 ps=1.27 w=1 l=0.15
X14 a_43_47.t1 B.t0 Y.t5 VNB.t1 sky130_fd_pr__nfet_01v8 ad=0.169 pd=1.82 as=0.08775 ps=0.92 w=0.65 l=0.15
X15 Y.t4 C.t3 a_125_297.t6 VPB.t6 sky130_fd_pr__pfet_01v8_hvt ad=0.135 pd=1.27 as=0.26 ps=2.52 w=1 l=0.15
R0 VGND.n3 VGND.n2 206.181
R1 VGND.n1 VGND.n0 199.739
R2 VGND.n5 VGND.n1 28.9887
R3 VGND.n0 VGND.t3 28.6159
R4 VGND.n0 VGND.t1 28.6159
R5 VGND.n2 VGND.t2 24.9236
R6 VGND.n2 VGND.t0 24.9236
R7 VGND.n5 VGND.n4 9.3005
R8 VGND VGND.n5 6.77697
R9 VGND.n3 VGND.n1 6.59623
R10 VGND.n4 VGND.n3 0.162902
R11 VGND.n4 VGND 0.0239375
R12 Y.n2 Y.n0 645.898
R13 Y.n2 Y.n1 585
R14 Y.n4 Y.n3 227.166
R15 Y.n6 Y.n5 185
R16 Y.n4 Y.n2 86.2244
R17 Y.n6 Y.n4 44.8423
R18 Y.n0 Y.t1 26.5955
R19 Y.n0 Y.t0 26.5955
R20 Y.n1 Y.t4 26.5955
R21 Y.n1 Y.t3 26.5955
R22 Y.n3 Y.t7 24.9236
R23 Y.n3 Y.t2 24.9236
R24 Y.n5 Y.t6 24.9236
R25 Y.n5 Y.t5 24.9236
R26 Y Y.n6 6.02403
R27 VPWR.n3 VPWR.t0 881.765
R28 VPWR.n4 VPWR.n2 607.212
R29 VPWR VPWR.t2 257.096
R30 VPWR.n4 VPWR.n3 35.4628
R31 VPWR.n6 VPWR.n5 34.6358
R32 VPWR.n2 VPWR.t3 26.5955
R33 VPWR.n2 VPWR.t1 26.5955
R34 VPWR.n6 VPWR.n0 26.3534
R35 VPWR.n9 VPWR.n8 9.3005
R36 VPWR.n7 VPWR.n6 9.3005
R37 VPWR.n5 VPWR.n1 9.3005
R38 VPWR.n9 VPWR.n0 8.28285
R39 VPWR VPWR.n9 6.77697
R40 VPWR.n5 VPWR.n4 5.27109
R41 VPWR.n3 VPWR.n1 1.65021
R42 VPWR.n0 VPWR 0.376971
R43 VPWR.n8 VPWR.n7 0.120292
R44 VPWR.n7 VPWR.n1 0.120292
R45 VPWR.n8 VPWR 0.0239375
R46 D.n1 D.t3 212.081
R47 D.n0 D.t2 212.081
R48 D D.n1 155.103
R49 D.n1 D.t1 139.78
R50 D.n0 D.t0 139.78
R51 D.n1 D.n0 61.346
R52 C.n1 C.t3 212.081
R53 C.n0 C.t2 212.081
R54 C C.n1 155.103
R55 C.n1 C.t1 139.78
R56 C.n0 C.t0 139.78
R57 C.n1 C.n0 61.346
R58 B.n1 B.t3 212.081
R59 B.n0 B.t2 212.081
R60 B B.n1 155.103
R61 B.n1 B.t1 139.78
R62 B.n0 B.t0 139.78
R63 B.n1 B.n0 61.346
R64 A.n0 A.t2 212.081
R65 A.n1 A.t3 212.081
R66 A A.n1 188.697
R67 A.n0 A.t0 139.78
R68 A.n1 A.t1 139.78
R69 A.n1 A.n0 67.1884
R70 VPB.t1 VPB.t6 556.386
R71 VPB.t2 VPB.t3 272.274
R72 VPB.t4 VPB.t5 248.599
R73 VPB.t7 VPB.t4 248.599
R74 VPB.t6 VPB.t7 248.599
R75 VPB.t0 VPB.t1 248.599
R76 VPB.t3 VPB.t0 248.599
R77 VPB VPB.t2 242.679
R78 VNB.t1 VNB.t6 2677.02
R79 VNB.t2 VNB.t3 1310.03
R80 VNB.t4 VNB.t5 1196.12
R81 VNB.t7 VNB.t4 1196.12
R82 VNB.t6 VNB.t7 1196.12
R83 VNB.t0 VNB.t1 1196.12
R84 VNB.t3 VNB.t0 1196.12
R85 VNB VNB.t2 1167.64
R86 a_491_47.t1 a_491_47.n1 341.774
R87 a_491_47.n1 a_491_47.t2 328.469
R88 a_491_47.n1 a_491_47.n0 185.304
R89 a_491_47.n0 a_491_47.t0 24.9236
R90 a_491_47.n0 a_491_47.t3 24.9236
R91 a_43_47.t1 a_43_47.n1 335.123
R92 a_43_47.n1 a_43_47.t2 322.219
R93 a_43_47.n1 a_43_47.n0 185
R94 a_43_47.n0 a_43_47.t0 24.9236
R95 a_43_47.n0 a_43_47.t3 24.9236
R96 a_125_297.n1 a_125_297.t5 410.918
R97 a_125_297.n2 a_125_297.t6 319.096
R98 a_125_297.n1 a_125_297.n0 295.765
R99 a_125_297.n4 a_125_297.n3 242.083
R100 a_125_297.n5 a_125_297.n4 202.177
R101 a_125_297.n2 a_125_297.n1 65.6899
R102 a_125_297.n4 a_125_297.n2 62.0965
R103 a_125_297.n3 a_125_297.t2 30.5355
R104 a_125_297.n3 a_125_297.t3 30.5355
R105 a_125_297.n5 a_125_297.t0 26.5955
R106 a_125_297.t1 a_125_297.n5 26.5955
R107 a_125_297.n0 a_125_297.t7 26.5955
R108 a_125_297.n0 a_125_297.t4 26.5955
C0 Y C 0.07192f
C1 VPB VPWR 0.13115f
C2 B VPWR 0.03346f
C3 VPB D 0.05833f
C4 VPB A 0.07255f
C5 VPB VGND 0.0138f
C6 B A 0.03898f
C7 VPWR D 0.02223f
C8 B VGND 0.02075f
C9 VPWR A 0.0534f
C10 VPWR VGND 0.04876f
C11 D VGND 0.03157f
C12 VPB C 0.059f
C13 A VGND 0.03494f
C14 VPB Y 0.01891f
C15 B C 0.00898f
C16 B Y 0.03092f
C17 VPWR C 0.02243f
C18 Y VPWR 0.02249f
C19 C D 0.03873f
C20 Y D 0.02224f
C21 C VGND 0.01981f
C22 Y A 0
C23 Y VGND 0.02816f
C24 B VPB 0.0591f
C25 VGND VNB 0.56658f
C26 Y VNB 0.0449f
C27 VPWR VNB 0.51025f
C28 D VNB 0.1613f
C29 C VNB 0.13428f
C30 B VNB 0.13726f
C31 A VNB 0.19614f
C32 VPB VNB 1.00775f
C33 a_125_297.t0 VNB 0.03562f
C34 a_125_297.t5 VNB 0.07268f
C35 a_125_297.t4 VNB 0.0337f
C36 a_125_297.t7 VNB 0.03587f
C37 a_125_297.n0 VNB 0.02985f
C38 a_125_297.n1 VNB 0.1026f
C39 a_125_297.t6 VNB 0.0745f
C40 a_125_297.n2 VNB 0.05885f
C41 a_125_297.t3 VNB 0.0371f
C42 a_125_297.t2 VNB 0.0371f
C43 a_125_297.n3 VNB 0.04788f
C44 a_125_297.n4 VNB 0.14847f
C45 a_125_297.n5 VNB 0.03168f
C46 a_125_297.t1 VNB 0.03562f
C47 a_43_47.t2 VNB 0.06402f
C48 a_43_47.t0 VNB 0.02719f
C49 a_43_47.t3 VNB 0.0267f
C50 a_43_47.n0 VNB 0.02512f
C51 a_43_47.n1 VNB 0.11124f
C52 a_43_47.t1 VNB 0.06659f
C53 a_491_47.t2 VNB 0.06261f
C54 a_491_47.t0 VNB 0.02552f
C55 a_491_47.t3 VNB 0.02704f
C56 a_491_47.n0 VNB 0.02448f
C57 a_491_47.n1 VNB 0.11234f
C58 a_491_47.t1 VNB 0.06496f
C59 VPB.t5 VNB 0.0863f
C60 VPB.t4 VNB 0.03815f
C61 VPB.t7 VNB 0.03815f
C62 VPB.t6 VNB 0.06177f
C63 VPB.t1 VNB 0.06177f
C64 VPB.t0 VNB 0.03815f
C65 VPB.t3 VNB 0.03997f
C66 VPB.t2 VNB 0.03952f
C67 A.n0 VNB 0.05125f
C68 A.n1 VNB 0.07416f
C69 B.n0 VNB 0.05111f
C70 B.n1 VNB 0.0571f
C71 C.n0 VNB 0.05173f
C72 C.n1 VNB 0.05778f
C73 D.n0 VNB 0.04641f
C74 D.n1 VNB 0.05185f
C75 VPWR.t2 VNB 0.05991f
C76 VPWR.n0 VNB 0.00596f
C77 VPWR.n1 VNB 0.29831f
C78 VPWR.t1 VNB 0.03106f
C79 VPWR.t3 VNB 0.03036f
C80 VPWR.n2 VNB 0.02064f
C81 VPWR.t0 VNB 0.05661f
C82 VPWR.n3 VNB 0.06293f
C83 VPWR.n4 VNB 0.01924f
C84 VPWR.n5 VNB 0.00679f
C85 VPWR.n6 VNB 0.01038f
C86 VPWR.n7 VNB 0.03328f
C87 VPWR.n8 VNB 0.01989f
C88 VPWR.n9 VNB 0.00256f
C89 Y.t0 VNB 0.03681f
C90 Y.t1 VNB 0.03681f
C91 Y.n0 VNB 0.03821f
C92 Y.t3 VNB 0.03898f
C93 Y.t4 VNB 0.03898f
C94 Y.n1 VNB 0.03569f
C95 Y.n2 VNB 0.07648f
C96 Y.t2 VNB 0.02641f
C97 Y.t7 VNB 0.02641f
C98 Y.n3 VNB 0.02704f
C99 Y.n4 VNB 0.08895f
C100 Y.t5 VNB 0.02623f
C101 Y.t6 VNB 0.02623f
C102 Y.n5 VNB 0.0232f
C103 Y.n6 VNB 0.01638f
C104 VGND.t1 VNB 0.02047f
C105 VGND.t3 VNB 0.02047f
C106 VGND.n0 VNB 0.0135f
C107 VGND.n1 VNB 0.03132f
C108 VGND.t0 VNB 0.0188f
C109 VGND.t2 VNB 0.0188f
C110 VGND.n2 VNB 0.01354f
C111 VGND.n3 VNB 0.32672f
C112 VGND.n4 VNB 0.02566f
C113 VGND.n5 VNB 0.00507f
.ends
