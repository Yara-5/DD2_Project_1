* NGSPICE file created from dd2_g5__and2_1.ext - technology: sky130A

.subckt dd2_g5__and2_1 A B VGND VNB VPB VPWR Y
X0 VGND A a_149_47# VNB sky130_fd_pr__nfet_01v8 ad=0.10725 pd=0.98 as=0.08775 ps=0.92 w=0.65 l=0.15
X1 a_149_47# B a_67_47# VNB sky130_fd_pr__nfet_01v8 ad=0.08775 pd=0.92 as=0.169 ps=1.82 w=0.65 l=0.15
X2 Y a_67_47# VPWR VPB sky130_fd_pr__pfet_01v8_hvt ad=0.26 pd=2.52 as=0.165 ps=1.33 w=1 l=0.15
X3 Y a_67_47# VGND VNB sky130_fd_pr__nfet_01v8 ad=0.169 pd=1.82 as=0.10725 ps=0.98 w=0.65 l=0.15
X4 VPWR A a_67_47# VPB sky130_fd_pr__pfet_01v8_hvt ad=0.165 pd=1.33 as=0.135 ps=1.27 w=1 l=0.15
X5 a_67_47# B VPWR VPB sky130_fd_pr__pfet_01v8_hvt ad=0.135 pd=1.27 as=0.26 ps=2.52 w=1 l=0.15
C0 B a_67_47# 0.05758f
C1 VGND Y 0.03406f
C2 VPB A 0.02588f
C3 VPWR a_67_47# 0.14039f
C4 VPB Y 0.01594f
C5 a_149_47# VPWR 0.00122f
C6 Y A 0.0012f
C7 VGND B 0.01666f
C8 VGND VPWR 0.02717f
C9 VPB B 0.03068f
C10 A B 0.03922f
C11 VPB VPWR 0.09203f
C12 Y B 0
C13 A VPWR 0.01882f
C14 a_149_47# a_67_47# 0.00693f
C15 Y VPWR 0.03264f
C16 VGND a_67_47# 0.07749f
C17 VGND a_149_47# 0.01168f
C18 VPWR B 0.01954f
C19 VPB a_67_47# 0.04991f
C20 A a_67_47# 0.06939f
C21 a_149_47# A 0
C22 Y a_67_47# 0.04575f
C23 Y a_149_47# 0
C24 VPB VGND 0.01324f
C25 VGND A 0.02435f
C26 VGND VNB 0.34334f
C27 Y VNB 0.16517f
C28 VPWR VNB 0.36908f
C29 VPB VNB 0.51617f
C30 a_149_47# VNB 0.06841f
.ends
