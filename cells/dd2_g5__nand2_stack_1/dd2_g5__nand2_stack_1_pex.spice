* NGSPICE file created from dd2_g5__nand2_stack_1.ext - technology: sky130A

.subckt dd2_g5__nand2_stack_1 A B VGND VNB VPB VPWR Y
X0 VPWR.t0 A.t2 Y.t1 VPB.t0 sky130_fd_pr__pfet_01v8_hvt ad=0.26 pd=2.52 as=0.135 ps=1.27 w=1 l=0.15
X1 Y.t2 B.t1 a_37_47.t2 VNB.t2 sky130_fd_pr__nfet_01v8 ad=0.08775 pd=0.92 as=0.169 ps=1.82 w=0.65 l=0.15
X2 Y.t3 B.t2 VPWR.t1 VPB.t1 sky130_fd_pr__pfet_01v8_hvt ad=0.135 pd=1.27 as=0.26 ps=2.52 w=1 l=0.15
X3 a_37_47.t3 B.t0 Y.t0 VNB.t3 sky130_fd_pr__nfet_01v8 ad=0.08775 pd=0.92 as=0.08775 ps=0.92 w=0.65 l=0.15
X4 a_37_47.t1 A.t0 VGND.t1 VNB.t1 sky130_fd_pr__nfet_01v8 ad=0.169 pd=1.82 as=0.08775 ps=0.92 w=0.65 l=0.15
X5 VGND.t0 A.t1 a_37_47.t0 VNB.t0 sky130_fd_pr__nfet_01v8 ad=0.08775 pd=0.92 as=0.08775 ps=0.92 w=0.65 l=0.15
R0 VGND.n1 VGND.n0 205.714
R1 VGND.n0 VGND.t1 24.9236
R2 VGND.n0 VGND.t0 24.9236
R3 VGND VGND.n1 14.3143
R4 VGND.n1 VGND 0.113395
R5 Y Y.n1 294.608
R6 Y Y.n0 191.024
R7 Y.n1 Y.t1 26.5955
R8 Y.n1 Y.t3 26.5955
R9 Y.n0 Y.t0 24.9236
R10 Y.n0 Y.t2 24.9236
R11 VPWR.n1 VPWR.t1 347.57
R12 VPWR.n2 VPWR.t0 264.082
R13 VPWR.n2 VPWR.n1 37.3093
R14 VPWR.n5 VPWR.n0 34.6358
R15 VPWR.n5 VPWR.n4 9.3005
R16 VPWR.n3 VPWR.n0 9.3005
R17 VPWR VPWR.n5 6.77697
R18 VPWR.n1 VPWR.n0 3.01226
R19 VPWR.n3 VPWR.n2 2.06415
R20 VPWR.n4 VPWR.n3 0.120292
R21 VPWR.n4 VPWR 0.0239375
R22 A.n0 A.t2 212.081
R23 A.n0 A.t0 201.125
R24 A A.n0 155.103
R25 A.n0 A.t1 139.78
R26 B.n0 B.t2 212.081
R27 B.n1 B.t1 192.363
R28 B B.n1 155.103
R29 B.n0 B.t0 139.78
R30 B.n1 B.n0 8.76414
R31 VPB VPB.t1 473.521
R32 VPB.t1 VPB.t0 248.599
R33 VNB.t0 VNB.t1 1196.12
R34 VNB.t3 VNB.t0 1196.12
R35 VNB.t2 VNB.t3 1196.12
R36 VNB VNB.t2 1082.2
R37 a_37_47.t1 a_37_47.n1 334.894
R38 a_37_47.n1 a_37_47.t2 331.325
R39 a_37_47.n1 a_37_47.n0 185
R40 a_37_47.n0 a_37_47.t0 24.9236
R41 a_37_47.n0 a_37_47.t3 24.9236
C0 B VGND 0.01653f
C1 VPWR B 0.02165f
C2 VPWR VGND 0.0263f
C3 B Y 0.07192f
C4 VGND Y 0.00989f
C5 VPWR Y 0.11173f
C6 A B 0.03922f
C7 A VGND 0.03047f
C8 A VPWR 0.03209f
C9 VPB B 0.04602f
C10 VPB VGND 0.01515f
C11 A Y 0.0142f
C12 VPB VPWR 0.11497f
C13 VPB Y 0.01731f
C14 VPB A 0.04893f
C15 VGND VNB 0.4058f
C16 Y VNB 0.1638f
C17 VPWR VNB 0.30775f
C18 A VNB 0.1552f
C19 B VNB 0.13954f
C20 VPB VNB 0.58512f
C21 a_37_47.t0 VNB 0.02539f
C22 a_37_47.t3 VNB 0.02686f
C23 a_37_47.n0 VNB 0.02288f
C24 a_37_47.t2 VNB 0.06532f
C25 a_37_47.n1 VNB 0.1045f
C26 a_37_47.t1 VNB 0.06739f
C27 VPB.t0 VNB 0.12658f
C28 VPB.t1 VNB 0.05762f
C29 B.n0 VNB 0.0357f
C30 B.n1 VNB 0.04738f
C31 A.n0 VNB 0.07878f
C32 VPWR.n0 VNB 0.0058f
C33 VPWR.t1 VNB 0.05673f
C34 VPWR.n1 VNB 0.02614f
C35 VPWR.t0 VNB 0.05686f
C36 VPWR.n2 VNB 0.05104f
C37 VPWR.n3 VNB 0.12452f
C38 VPWR.n4 VNB 0.01801f
C39 VPWR.n5 VNB 0.00638f
C40 Y.t0 VNB 0.02675f
C41 Y.t2 VNB 0.03163f
C42 Y.n0 VNB 0.02296f
C43 Y.t1 VNB 0.03735f
C44 Y.t3 VNB 0.03945f
C45 Y.n1 VNB 0.06947f
C46 VGND.t1 VNB 0.02476f
C47 VGND.t0 VNB 0.01941f
C48 VGND.n0 VNB 0.01286f
C49 VGND.n1 VNB 0.10184f
.ends
