* NGSPICE file created from dd2_g5__maj4_opt_1.ext - technology: sky130A

.subckt dd2_g5__maj4_opt_1 A B C D VGND VNB VPB VPWR Y
X0 a_237_47.t0 C.t1 a_153_47.t0 VNB.t0 sky130_fd_pr__nfet_01v8 ad=0.0858 pd=0.85 as=0.0702 ps=0.79 w=0.52 l=0.15
X1 a_237_47.t1 C.t2 a_525_297.t0 VPB.t1 sky130_fd_pr__pfet_01v8_hvt ad=0.26 pd=2.52 as=0.135 ps=1.27 w=1 l=0.15
X2 a_71_297.t3 A.t1 a_237_47.t2 VPB.t5 sky130_fd_pr__pfet_01v8_hvt ad=0.165 pd=1.33 as=0.165 ps=1.33 w=1 l=0.15
X3 a_525_297.t1 D.t2 a_71_297.t2 VPB.t3 sky130_fd_pr__pfet_01v8_hvt ad=0.135 pd=1.27 as=0.165 ps=1.33 w=1 l=0.15
X4 VGND.t3 D.t0 a_429_47.t1 VNB.t3 sky130_fd_pr__nfet_01v8 ad=0.0702 pd=0.79 as=0.0858 ps=0.85 w=0.52 l=0.15
X5 a_429_47.t2 A.t0 a_333_47.t0 VNB.t5 sky130_fd_pr__nfet_01v8 ad=0.0858 pd=0.85 as=0.0858 ps=0.85 w=0.52 l=0.15
X6 a_237_47.t4 B.t1 a_71_297.t4 VPB.t6 sky130_fd_pr__pfet_01v8_hvt ad=0.165 pd=1.33 as=0.165 ps=1.33 w=1 l=0.15
X7 Y.t1 a_237_47.t6 VPWR.t2 VPB.t4 sky130_fd_pr__pfet_01v8_hvt ad=0.26 pd=2.52 as=0.26 ps=2.52 w=1 l=0.15
X8 a_71_297.t0 C.t3 VPWR.t0 VPB.t0 sky130_fd_pr__pfet_01v8_hvt ad=0.165 pd=1.33 as=0.135 ps=1.27 w=1 l=0.15
X9 a_429_47.t0 C.t0 VGND.t1 VNB.t1 sky130_fd_pr__nfet_01v8 ad=0.1352 pd=1.56 as=0.0702 ps=0.79 w=0.52 l=0.15
X10 VPWR.t1 D.t3 a_71_297.t1 VPB.t2 sky130_fd_pr__pfet_01v8_hvt ad=0.135 pd=1.27 as=0.26 ps=2.52 w=1 l=0.15
X11 a_153_47.t1 D.t1 VGND.t2 VNB.t2 sky130_fd_pr__nfet_01v8 ad=0.0702 pd=0.79 as=0.1352 ps=1.56 w=0.52 l=0.15
X12 Y.t0 a_237_47.t5 VGND.t0 VNB.t4 sky130_fd_pr__nfet_01v8 ad=0.169 pd=1.82 as=0.169 ps=1.82 w=0.65 l=0.15
X13 a_333_47.t1 B.t0 a_237_47.t3 VNB.t6 sky130_fd_pr__nfet_01v8 ad=0.0858 pd=0.85 as=0.0858 ps=0.85 w=0.52 l=0.15
R0 VGND.n0 VGND.t2 230.893
R1 VGND.n5 VGND.n4 199.739
R2 VGND.n3 VGND.t0 155.357
R3 VGND.n12 VGND.n11 34.6358
R4 VGND.n11 VGND.n10 34.6358
R5 VGND.n10 VGND.n2 34.6358
R6 VGND.n6 VGND.n2 34.6358
R7 VGND.n4 VGND.t3 31.1543
R8 VGND.n4 VGND.t1 31.1543
R9 VGND.n5 VGND.n3 11.7301
R10 VGND.n7 VGND.n6 9.3005
R11 VGND.n8 VGND.n2 9.3005
R12 VGND.n10 VGND.n9 9.3005
R13 VGND.n11 VGND.n1 9.3005
R14 VGND.n13 VGND.n12 9.3005
R15 VGND.n15 VGND.n14 9.3005
R16 VGND VGND.n15 6.77697
R17 VGND.n15 VGND.n0 6.4005
R18 VGND.n6 VGND.n5 4.89462
R19 VGND.n12 VGND.n0 3.38874
R20 VGND.n7 VGND.n3 0.86083
R21 VGND.n14 VGND.n13 0.120292
R22 VGND.n13 VGND.n1 0.120292
R23 VGND.n9 VGND.n1 0.120292
R24 VGND.n9 VGND.n8 0.120292
R25 VGND.n8 VGND.n7 0.120292
R26 VGND.n14 VGND 0.0239375
R27 Y.n0 Y.t1 389.846
R28 Y.n0 Y.t0 209.923
R29 Y.n1 Y 6.4005
R30 Y Y.n1 3.2005
R31 Y.n1 Y.n0 0.213833
R32 VPWR.n2 VPWR.n1 607.212
R33 VPWR.n3 VPWR.t2 354.49
R34 VPWR.n6 VPWR.n0 34.6358
R35 VPWR.n1 VPWR.t1 26.5955
R36 VPWR.n1 VPWR.t0 26.5955
R37 VPWR.n3 VPWR.n2 26.4239
R38 VPWR.n2 VPWR.n0 15.8123
R39 VPWR.n6 VPWR.n5 9.3005
R40 VPWR.n4 VPWR.n0 9.3005
R41 VPWR VPWR.n6 6.77697
R42 VPWR.n4 VPWR.n3 0.147983
R43 VPWR.n5 VPWR.n4 0.120292
R44 VPWR.n5 VPWR 0.0239375
R45 A.n0 A.t1 241.536
R46 A.n0 A.t0 190.123
R47 A A.n0 155.103
R48 B.n0 B.t1 241.536
R49 B.n0 B.t0 190.123
R50 B B.n0 155.103
R51 C.n1 C.t3 241.536
R52 C.n0 C.t2 241.536
R53 C.n1 C.t1 190.123
R54 C.n0 C.t0 190.123
R55 C.n2 C.n0 172.45
R56 C.n2 C.n1 152
R57 C C.n2 3.10353
R58 D.n1 D.t3 241.536
R59 D.n0 D.t2 241.536
R60 D.n1 D.t1 190.123
R61 D.n0 D.t0 190.123
R62 D.n2 D.n0 172.45
R63 D.n2 D.n1 152
R64 D D.n2 3.10353
R65 VPB.t1 VPB.t4 556.386
R66 VPB VPB.t2 325.546
R67 VPB.t5 VPB.t3 284.113
R68 VPB.t6 VPB.t5 284.113
R69 VPB.t0 VPB.t6 284.113
R70 VPB.t3 VPB.t1 248.599
R71 VPB.t2 VPB.t0 248.599
R72 VNB.t1 VNB.t4 2677.02
R73 VNB VNB.t2 1566.34
R74 VNB.t5 VNB.t3 1366.99
R75 VNB.t6 VNB.t5 1366.99
R76 VNB.t0 VNB.t6 1366.99
R77 VNB.t3 VNB.t1 1196.12
R78 VNB.t2 VNB.t0 1196.12
R79 a_429_47.t0 a_429_47.n0 468.067
R80 a_429_47.n0 a_429_47.t1 38.0774
R81 a_429_47.n0 a_429_47.t2 38.0774
R82 a_333_47.t0 a_333_47.t1 76.1543
R83 a_153_47.t0 a_153_47.t1 62.3082
R84 a_525_297.t0 a_525_297.t1 53.1905
R85 a_71_297.n1 a_71_297.n0 356.096
R86 a_71_297.n1 a_71_297.t1 281.969
R87 a_71_297.n2 a_71_297.n1 189.28
R88 a_71_297.n0 a_71_297.t2 32.5055
R89 a_71_297.n0 a_71_297.t3 32.5055
R90 a_71_297.n2 a_71_297.t4 32.5055
R91 a_71_297.t0 a_71_297.n2 32.5055
R92 a_237_47.n2 a_237_47.n1 585
R93 a_237_47.n2 a_237_47.n0 291.452
R94 a_237_47.n3 a_237_47.t6 241.536
R95 a_237_47.t1 a_237_47.n4 228.411
R96 a_237_47.n4 a_237_47.n3 210.617
R97 a_237_47.n3 a_237_47.t5 169.237
R98 a_237_47.n4 a_237_47.n2 89.224
R99 a_237_47.n0 a_237_47.t0 38.0774
R100 a_237_47.n0 a_237_47.t3 38.0774
R101 a_237_47.n1 a_237_47.t4 32.5055
R102 a_237_47.n1 a_237_47.t2 32.5055
C0 Y D 0.00106f
C1 B Y 0
C2 VPWR Y 0.0319f
C3 C D 0.20043f
C4 A D 0.05432f
C5 VGND Y 0.0351f
C6 VPB Y 0.01499f
C7 C B 0.05343f
C8 A B 0.03951f
C9 C VPWR 0.04832f
C10 VPWR A 0.00703f
C11 VGND C 0.03553f
C12 VGND A 0.01459f
C13 VPB C 0.06846f
C14 VPB A 0.02683f
C15 B D 0.01199f
C16 VPWR D 0.02446f
C17 VGND D 0.09147f
C18 VPWR B 0.00702f
C19 VPB D 0.05912f
C20 C Y 0.00192f
C21 A Y 0
C22 VGND B 0.01405f
C23 VPB B 0.02683f
C24 VGND VPWR 0.01998f
C25 VPB VPWR 0.13573f
C26 C A 0.01156f
C27 VPB VGND 0.01495f
C28 VGND VNB 0.58707f
C29 Y VNB 0.07253f
C30 VPWR VNB 0.45722f
C31 A VNB 0.08705f
C32 B VNB 0.08661f
C33 C VNB 0.17167f
C34 D VNB 0.19991f
C35 VPB VNB 1.01293f
C36 a_237_47.t3 VNB 0.0363f
C37 a_237_47.t0 VNB 0.04024f
C38 a_237_47.n0 VNB 0.06413f
C39 a_237_47.t2 VNB 0.06051f
C40 a_237_47.t4 VNB 0.0599f
C41 a_237_47.n1 VNB 0.05893f
C42 a_237_47.n2 VNB 0.28633f
C43 a_237_47.n3 VNB 0.06798f
C44 a_237_47.n4 VNB 0.20555f
C45 a_237_47.t1 VNB 0.12396f
C46 a_71_297.t4 VNB 0.05128f
C47 a_71_297.t2 VNB 0.0554f
C48 a_71_297.t3 VNB 0.05189f
C49 a_71_297.n0 VNB 0.05317f
C50 a_71_297.t1 VNB 0.11536f
C51 a_71_297.n1 VNB 0.21007f
C52 a_71_297.n2 VNB 0.04169f
C53 a_71_297.t0 VNB 0.057f
C54 a_525_297.t1 VNB 0.05128f
C55 a_525_297.t0 VNB 0.05288f
C56 a_153_47.t1 VNB 0.03159f
C57 a_153_47.t0 VNB 0.03269f
C58 a_333_47.t1 VNB 0.0313f
C59 a_333_47.t0 VNB 0.03172f
C60 a_429_47.t1 VNB 0.03695f
C61 a_429_47.t2 VNB 0.03453f
C62 a_429_47.n0 VNB 0.06823f
C63 a_429_47.t0 VNB 0.09904f
C64 VPB.t4 VNB 0.12f
C65 VPB.t1 VNB 0.06045f
C66 VPB.t3 VNB 0.04f
C67 VPB.t5 VNB 0.04267f
C68 VPB.t6 VNB 0.04267f
C69 VPB.t0 VNB 0.04f
C70 VPB.t2 VNB 0.04311f
C71 D.n0 VNB 0.08802f
C72 D.n1 VNB 0.07153f
C73 D.n2 VNB 0.25422f
C74 C.n0 VNB 0.09209f
C75 C.n1 VNB 0.07484f
C76 C.n2 VNB 0.26598f
C77 B.n0 VNB 0.06333f
C78 A.n0 VNB 0.0646f
C79 VPWR.n0 VNB 0.009f
C80 VPWR.t0 VNB 0.04683f
C81 VPWR.t1 VNB 0.04523f
C82 VPWR.n1 VNB 0.02165f
C83 VPWR.n2 VNB 0.02176f
C84 VPWR.t2 VNB 0.06994f
C85 VPWR.n3 VNB 0.39312f
C86 VPWR.n4 VNB 0.04437f
C87 VPWR.n5 VNB 0.02087f
C88 VPWR.n6 VNB 0.00739f
C89 Y.t1 VNB 0.07614f
C90 Y.t0 VNB 0.04656f
C91 Y.n0 VNB 0.05126f
C92 Y.n1 VNB 0.00557f
C93 VGND.t2 VNB 0.03764f
C94 VGND.n0 VNB 0.02172f
C95 VGND.n1 VNB 0.02395f
C96 VGND.n2 VNB 0.00848f
C97 VGND.t0 VNB 0.03862f
C98 VGND.n3 VNB 0.06101f
C99 VGND.t1 VNB 0.02872f
C100 VGND.t3 VNB 0.02762f
C101 VGND.n4 VNB 0.00834f
C102 VGND.n5 VNB 0.02315f
C103 VGND.n6 VNB 0.00484f
C104 VGND.n7 VNB 0.11122f
C105 VGND.n8 VNB 0.02395f
C106 VGND.n9 VNB 0.02395f
C107 VGND.n10 VNB 0.00848f
C108 VGND.n11 VNB 0.00848f
C109 VGND.n12 VNB 0.00466f
C110 VGND.n13 VNB 0.02395f
C111 VGND.n14 VNB 0.01432f
C112 VGND.n15 VNB 0.00161f
.ends
