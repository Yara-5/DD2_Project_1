* NGSPICE file created from dd2_g5__maj4_opt_1.ext - technology: sky130A

.subckt dd2_g5__maj4_opt_1 A B C D VGND VNB VPB VPWR Y
X0 a_237_47# C a_153_47# VNB sky130_fd_pr__nfet_01v8 ad=0.0858 pd=0.85 as=0.0702 ps=0.79 w=0.52 l=0.15
X1 a_237_47# C a_525_297# VPB sky130_fd_pr__pfet_01v8_hvt ad=0.26 pd=2.52 as=0.135 ps=1.27 w=1 l=0.15
X2 a_71_297# A a_237_47# VPB sky130_fd_pr__pfet_01v8_hvt ad=0.165 pd=1.33 as=0.165 ps=1.33 w=1 l=0.15
X3 a_525_297# D a_71_297# VPB sky130_fd_pr__pfet_01v8_hvt ad=0.135 pd=1.27 as=0.165 ps=1.33 w=1 l=0.15
X4 VGND D a_429_47# VNB sky130_fd_pr__nfet_01v8 ad=0.0702 pd=0.79 as=0.0858 ps=0.85 w=0.52 l=0.15
X5 a_429_47# A a_333_47# VNB sky130_fd_pr__nfet_01v8 ad=0.0858 pd=0.85 as=0.0858 ps=0.85 w=0.52 l=0.15
X6 a_237_47# B a_71_297# VPB sky130_fd_pr__pfet_01v8_hvt ad=0.165 pd=1.33 as=0.165 ps=1.33 w=1 l=0.15
X7 Y a_237_47# VPWR VPB sky130_fd_pr__pfet_01v8_hvt ad=0.26 pd=2.52 as=0.26 ps=2.52 w=1 l=0.15
X8 a_71_297# C VPWR VPB sky130_fd_pr__pfet_01v8_hvt ad=0.165 pd=1.33 as=0.135 ps=1.27 w=1 l=0.15
X9 a_429_47# C VGND VNB sky130_fd_pr__nfet_01v8 ad=0.1352 pd=1.56 as=0.0702 ps=0.79 w=0.52 l=0.15
X10 VPWR D a_71_297# VPB sky130_fd_pr__pfet_01v8_hvt ad=0.135 pd=1.27 as=0.26 ps=2.52 w=1 l=0.15
X11 a_153_47# D VGND VNB sky130_fd_pr__nfet_01v8 ad=0.0702 pd=0.79 as=0.1352 ps=1.56 w=0.52 l=0.15
X12 Y a_237_47# VGND VNB sky130_fd_pr__nfet_01v8 ad=0.169 pd=1.82 as=0.169 ps=1.82 w=0.65 l=0.15
X13 a_333_47# B a_237_47# VNB sky130_fd_pr__nfet_01v8 ad=0.0858 pd=0.85 as=0.0858 ps=0.85 w=0.52 l=0.15
C0 a_525_297# a_71_297# 0.00389f
C1 C Y 0.00192f
C2 VPWR Y 0.0319f
C3 a_525_297# C 0.00404f
C4 VPWR a_525_297# 0.00863f
C5 a_237_47# a_71_297# 0.16899f
C6 VPB a_429_47# 0.00183f
C7 VPB A 0.02683f
C8 B VGND 0.01405f
C9 a_333_47# a_237_47# 0.00494f
C10 a_237_47# C 0.18457f
C11 VPWR a_237_47# 0.15883f
C12 D a_71_297# 0.03429f
C13 D a_333_47# 0.00316f
C14 A Y 0
C15 VGND a_153_47# 0.00705f
C16 D C 0.20043f
C17 D VPWR 0.02446f
C18 a_525_297# a_429_47# 0
C19 VPB B 0.02683f
C20 a_237_47# a_429_47# 0.01721f
C21 A a_237_47# 0.02174f
C22 a_333_47# a_71_297# 0
C23 C a_71_297# 0.0493f
C24 VPB VGND 0.01495f
C25 VPWR a_71_297# 0.1589f
C26 VPWR C 0.04832f
C27 B Y 0
C28 D a_429_47# 0.03906f
C29 D A 0.05432f
C30 B a_237_47# 0.01299f
C31 VGND Y 0.0351f
C32 a_71_297# a_429_47# 0
C33 A a_71_297# 0.01264f
C34 a_333_47# a_429_47# 0.00267f
C35 a_333_47# A 0
C36 VGND a_237_47# 0.10719f
C37 C a_429_47# 0.02668f
C38 A C 0.01156f
C39 VPWR a_429_47# 0
C40 VPWR A 0.00703f
C41 D B 0.01199f
C42 a_153_47# a_237_47# 0.00661f
C43 VPB Y 0.01499f
C44 D VGND 0.09147f
C45 B a_71_297# 0.02077f
C46 D a_153_47# 0.00188f
C47 VPB a_237_47# 0.07537f
C48 a_333_47# B 0
C49 B C 0.05343f
C50 VPWR B 0.00702f
C51 A a_429_47# 0.00349f
C52 VGND a_71_297# 0.00112f
C53 a_333_47# VGND 0.0094f
C54 VGND C 0.03553f
C55 VPWR VGND 0.01998f
C56 D VPB 0.05912f
C57 a_237_47# Y 0.04668f
C58 a_525_297# a_237_47# 0.01641f
C59 B a_429_47# 0.00138f
C60 B A 0.03951f
C61 VPB a_71_297# 0.01855f
C62 D Y 0.00106f
C63 VPB C 0.06846f
C64 D a_525_297# 0
C65 VPWR VPB 0.13573f
C66 VGND a_429_47# 0.07506f
C67 A VGND 0.01459f
C68 D a_237_47# 0.13274f
C69 VGND VNB 0.56368f
C70 Y VNB 0.2405f
C71 VPWR VNB 0.60609f
C72 VPB VNB 0.95915f
C73 a_429_47# VNB 0.0102f
C74 a_153_47# VNB 0.0819f
C75 a_525_297# VNB 0.0962f
C76 a_71_297# VNB 0.19442f
.ends
