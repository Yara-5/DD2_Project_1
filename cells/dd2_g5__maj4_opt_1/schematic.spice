* Intended schematic from supplied transistor connections.
* SKY130 model files use um-scale W/L convention; load the course model setup.
.subckt dd2_g5__maj4_opt_1 A B C D VGND VNB VPB VPWR Y
XN1 n1_d1 A n1_d2 VNB sky130_fd_pr__nfet_01v8 w=0.52 l=0.15
XN2 n1 B n1_d1 VNB sky130_fd_pr__nfet_01v8 w=0.52 l=0.15
XN3 n1_d2 C VGND VNB sky130_fd_pr__nfet_01v8 w=0.52 l=0.15
XN4 n1_d2 D VGND VNB sky130_fd_pr__nfet_01v8 w=0.52 l=0.15
XN5 n1 C n1_d3 VNB sky130_fd_pr__nfet_01v8 w=0.52 l=0.15
XN6 n1_d3 D VGND VNB sky130_fd_pr__nfet_01v8 w=0.52 l=0.15
XP1 n1_u1 A n1 VPB sky130_fd_pr__pfet_01v8_hvt w=1 l=0.15
XP2 n1_u1 B n1 VPB sky130_fd_pr__pfet_01v8_hvt w=1 l=0.15
XP3 n1_u2 C n1 VPB sky130_fd_pr__pfet_01v8_hvt w=1 l=0.15
XP4 n1_u1 D n1_u2 VPB sky130_fd_pr__pfet_01v8_hvt w=1 l=0.15
XP5 VPWR C n1_u1 VPB sky130_fd_pr__pfet_01v8_hvt w=1 l=0.15
XP6 VPWR D n1_u1 VPB sky130_fd_pr__pfet_01v8_hvt w=1 l=0.15
XN7 Y n1 VGND VNB sky130_fd_pr__nfet_01v8 w=0.65 l=0.15
XP7 VPWR n1 Y VPB sky130_fd_pr__pfet_01v8_hvt w=1 l=0.15
.ends dd2_g5__maj4_opt_1
