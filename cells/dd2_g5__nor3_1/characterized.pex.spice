* NGSPICE file created from dd2_g5__nor3_1.ext - technology: sky130A

.subckt dd2_g5__nor3_1 A B C VGND VNB VPB VPWR Y
X0 Y.t0 C.t1 a_203_297.t0 VPB.t1 sky130_fd_pr__pfet_01v8_hvt ad=0.26 pd=2.52 as=0.135 ps=1.27 w=1 l=0.15
X1 a_203_297.t1 B.t1 a_111_297.t1 VPB.t2 sky130_fd_pr__pfet_01v8_hvt ad=0.135 pd=1.27 as=0.155 ps=1.31 w=1 l=0.15
X2 a_111_297.t0 A.t1 VPWR.t0 VPB.t0 sky130_fd_pr__pfet_01v8_hvt ad=0.155 pd=1.31 as=0.26 ps=2.52 w=1 l=0.15
X3 Y.t3 A.t0 VGND.t2 VNB.t0 sky130_fd_pr__nfet_01v8 ad=0.10075 pd=0.96 as=0.169 ps=1.82 w=0.65 l=0.15
X4 VGND.t1 B.t0 Y.t2 VNB.t2 sky130_fd_pr__nfet_01v8 ad=0.08775 pd=0.92 as=0.10075 ps=0.96 w=0.65 l=0.15
X5 Y.t1 C.t0 VGND.t0 VNB.t1 sky130_fd_pr__nfet_01v8 ad=0.169 pd=1.82 as=0.08775 ps=0.92 w=0.65 l=0.15
R0 VGND.n2 VGND.t2 282.817
R1 VGND.n1 VGND.n0 205.208
R2 VGND.n0 VGND.t0 24.9236
R3 VGND.n0 VGND.t1 24.9236
R4 VGND.n2 VGND.n1 6.39036
R5 VGND VGND.n2 3.10353
R6 VGND.n1 VGND 0.511893
R7 Y.n3 Y.t0 958.693
R8 Y.n0 Y.t1 267.187
R9 Y.n2 Y.n1 185
R10 Y.n1 Y.t2 28.6159
R11 Y.n1 Y.t3 28.6159
R12 Y.n0 Y 19.2005
R13 Y.n3 Y.n2 4.68995
R14 Y Y.n3 0.678337
R15 Y.n2 Y.n0 0.674184
R16 VPWR VPWR.t0 875.817
R17 VPWR VPWR.n0 7.31941
R18 VPWR.n0 VPWR 7.10903
R19 VPWR.n0 VPWR 2.67179
R20 C.n0 C.t1 241.536
R21 C.n0 C.t0 169.237
R22 C C.n0 155.103
R23 B.n0 B.t1 241.536
R24 B.n0 B.t0 169.237
R25 B B.n0 155.103
R26 A.n0 A.t1 230.155
R27 A.n0 A.t0 157.856
R28 A A.n0 155.103
R29 VPB.t0 VPB.t2 272.274
R30 VPB.t2 VPB.t1 248.599
R31 VPB VPB.t0 201.246
R32 VNB.t0 VNB.t2 1310.03
R33 VNB.t2 VNB.t1 1196.12
R34 VNB VNB.t0 968.285
R35 a_203_297.t0 a_203_297.t1 53.1905
R36 a_111_297.t0 a_111_297.t1 61.0705
C0 VPWR C 0.01349f
C1 VGND VPB 0.00775f
C2 Y VPB 0.01588f
C3 VPWR B 0.01435f
C4 Y VGND 0.07517f
C5 VPWR A 0.02473f
C6 VPWR VPB 0.06179f
C7 C B 0.03922f
C8 VPWR VGND 0.02382f
C9 Y VPWR 0.0335f
C10 A B 0.02424f
C11 C VPB 0.02938f
C12 VPB B 0.02563f
C13 VGND C 0.01501f
C14 Y C 0.04029f
C15 VGND B 0.01656f
C16 Y B 0.05653f
C17 A VPB 0.03813f
C18 A VGND 0.02775f
C19 Y A 0.03157f
C20 VGND VNB 0.35428f
C21 Y VNB 0.08459f
C22 VPWR VNB 0.38555f
C23 C VNB 0.11182f
C24 B VNB 0.07651f
C25 A VNB 0.1285f
C26 VPB VNB 0.46779f
C27 a_111_297.t1 VNB 0.04106f
C28 a_111_297.t0 VNB 0.0334f
C29 a_203_297.t1 VNB 0.03928f
C30 a_203_297.t0 VNB 0.03295f
C31 VPB.t1 VNB 0.07078f
C32 VPB.t2 VNB 0.03539f
C33 VPB.t0 VNB 0.03217f
C34 A.n0 VNB 0.05918f
C35 B.n0 VNB 0.05748f
C36 C.n0 VNB 0.04473f
C37 VPWR.t0 VNB 0.05077f
C38 VPWR.n0 VNB 0.0028f
C39 Y.t1 VNB 0.05676f
C40 Y.n0 VNB 0.04636f
C41 Y.t2 VNB 0.03183f
C42 Y.t3 VNB 0.02626f
C43 Y.n1 VNB 0.02238f
C44 Y.n2 VNB 0.00219f
C45 Y.t0 VNB 0.08063f
C46 Y.n3 VNB 0.0716f
C47 VGND.t0 VNB 0.02022f
C48 VGND.t1 VNB 0.0248f
C49 VGND.n0 VNB 0.00963f
C50 VGND.n1 VNB 0.03437f
C51 VGND.t2 VNB 0.02982f
C52 VGND.n2 VNB 0.02174f
.ends
