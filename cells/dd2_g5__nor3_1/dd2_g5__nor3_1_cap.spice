* NGSPICE file created from dd2_g5__nor3_1.ext - technology: sky130A

.subckt dd2_g5__nor3_1 A B C VGND VNB VPB VPWR Y
X0 Y C a_203_297# VPB sky130_fd_pr__pfet_01v8_hvt ad=0.26 pd=2.52 as=0.135 ps=1.27 w=1 l=0.15
X1 a_203_297# B a_111_297# VPB sky130_fd_pr__pfet_01v8_hvt ad=0.135 pd=1.27 as=0.155 ps=1.31 w=1 l=0.15
X2 a_111_297# A VPWR VPB sky130_fd_pr__pfet_01v8_hvt ad=0.155 pd=1.31 as=0.26 ps=2.52 w=1 l=0.15
X3 Y A VGND VNB sky130_fd_pr__nfet_01v8 ad=0.10075 pd=0.96 as=0.169 ps=1.82 w=0.65 l=0.15
X4 VGND B Y VNB sky130_fd_pr__nfet_01v8 ad=0.08775 pd=0.92 as=0.10075 ps=0.96 w=0.65 l=0.15
X5 Y C VGND VNB sky130_fd_pr__nfet_01v8 ad=0.169 pd=1.82 as=0.08775 ps=0.92 w=0.65 l=0.15
C0 VPWR a_203_297# 0.01188f
C1 a_111_297# B 0
C2 VPWR VPB 0.06307f
C3 VGND a_203_297# 0.00166f
C4 VPWR B 0.01579f
C5 VGND VPB 0.0069f
C6 A VPB 0.03813f
C7 VGND B 0.01656f
C8 a_111_297# Y 0.01401f
C9 C VPB 0.02938f
C10 A B 0.02424f
C11 C B 0.03922f
C12 VPWR Y 0.05285f
C13 VPWR a_111_297# 0.01549f
C14 VGND Y 0.07551f
C15 B a_203_297# 0
C16 Y A 0.03294f
C17 B VPB 0.02563f
C18 C Y 0.04647f
C19 VGND a_111_297# 0.0019f
C20 VPWR VGND 0.02326f
C21 Y a_203_297# 0.01401f
C22 VPWR A 0.02846f
C23 Y VPB 0.01949f
C24 VPWR C 0.01285f
C25 Y B 0.05966f
C26 VGND A 0.02775f
C27 VGND C 0.01484f
C28 VGND VNB 0.27007f
C29 Y VNB 0.14349f
C30 VPWR VNB 0.28681f
C31 VPB VNB 0.42757f
C32 a_203_297# VNB 0.07531f
C33 a_111_297# VNB 0.0839f
.ends
