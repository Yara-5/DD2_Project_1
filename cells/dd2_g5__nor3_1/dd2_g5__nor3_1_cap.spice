* NGSPICE file created from dd2_g5__nor3_1.ext - technology: sky130A

.subckt dd2_g5__nor3_1 A B C VGND VNB VPB VPWR Y
X0 Y C a_203_297# VPB sky130_fd_pr__pfet_01v8_hvt ad=0.26 pd=2.52 as=0.135 ps=1.27 w=1 l=0.15
X1 a_203_297# B a_111_297# VPB sky130_fd_pr__pfet_01v8_hvt ad=0.135 pd=1.27 as=0.155 ps=1.31 w=1 l=0.15
X2 a_111_297# A VPWR VPB sky130_fd_pr__pfet_01v8_hvt ad=0.155 pd=1.31 as=0.26 ps=2.52 w=1 l=0.15
X3 Y A VGND VNB sky130_fd_pr__nfet_01v8 ad=0.10075 pd=0.96 as=0.169 ps=1.82 w=0.65 l=0.15
X4 VGND B Y VNB sky130_fd_pr__nfet_01v8 ad=0.08775 pd=0.92 as=0.10075 ps=0.96 w=0.65 l=0.15
X5 Y C VGND VNB sky130_fd_pr__nfet_01v8 ad=0.169 pd=1.82 as=0.08775 ps=0.92 w=0.65 l=0.15
C0 Y a_203_297# 0.00953f
C1 VPWR VGND 0.02382f
C2 VPWR A 0.02473f
C3 Y VPB 0.01588f
C4 VPWR C 0.01349f
C5 Y B 0.05653f
C6 VGND A 0.02775f
C7 a_111_297# B 0
C8 VGND C 0.01501f
C9 VPWR a_203_297# 0.01026f
C10 VPWR VPB 0.06179f
C11 VGND a_203_297# 0.00166f
C12 VPWR B 0.01435f
C13 VGND VPB 0.00775f
C14 A VPB 0.03813f
C15 a_111_297# Y 0.01046f
C16 VGND B 0.01656f
C17 C VPB 0.02938f
C18 A B 0.02424f
C19 C B 0.03922f
C20 VPWR Y 0.0335f
C21 VPWR a_111_297# 0.01265f
C22 VGND Y 0.07517f
C23 B a_203_297# 0
C24 Y A 0.03157f
C25 B VPB 0.02563f
C26 C Y 0.04029f
C27 VGND a_111_297# 0.0019f
C28 VGND VNB 0.2701f
C29 Y VNB 0.12176f
C30 VPWR VNB 0.27957f
C31 VPB VNB 0.42757f
C32 a_203_297# VNB 0.07531f
C33 a_111_297# VNB 0.0839f
.ends
