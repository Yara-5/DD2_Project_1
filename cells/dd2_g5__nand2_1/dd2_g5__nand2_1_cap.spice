* NGSPICE file created from dd2_g5__nand2_1.ext - technology: sky130A

.subckt dd2_g5__nand2_1 A B VGND VNB VPB VPWR Y
X0 Y A VPWR VPB sky130_fd_pr__pfet_01v8_hvt ad=0.135 pd=1.27 as=0.26 ps=2.52 w=1 l=0.15
X1 VGND B a_111_47# VNB sky130_fd_pr__nfet_01v8 ad=0.169 pd=1.82 as=0.08775 ps=0.92 w=0.65 l=0.15
X2 a_111_47# A Y VNB sky130_fd_pr__nfet_01v8 ad=0.08775 pd=0.92 as=0.169 ps=1.82 w=0.65 l=0.15
X3 VPWR B Y VPB sky130_fd_pr__pfet_01v8_hvt ad=0.26 pd=2.52 as=0.135 ps=1.27 w=1 l=0.15
C0 B VPWR 0.02635f
C1 Y VPWR 0.09774f
C2 a_111_47# Y 0.00828f
C3 B VGND 0.02642f
C4 Y VGND 0.05186f
C5 VPB A 0.0375f
C6 a_111_47# VPWR 0
C7 VGND VPWR 0.02165f
C8 a_111_47# VGND 0.00943f
C9 B VPB 0.02945f
C10 VPB Y 0.00909f
C11 B A 0.02626f
C12 Y A 0.05969f
C13 B Y 0.03327f
C14 VPB VPWR 0.0573f
C15 VPWR A 0.02686f
C16 VPB VGND 0.00717f
C17 VGND A 0.01368f
C18 VGND VNB 0.27993f
C19 Y VNB 0.11499f
C20 VPWR VNB 0.2839f
C21 VPB VNB 0.33898f
C22 a_111_47# VNB 0.04772f
.ends
