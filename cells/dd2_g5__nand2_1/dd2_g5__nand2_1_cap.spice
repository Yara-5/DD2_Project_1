* NGSPICE file created from dd2_g5__nand2_1.ext - technology: sky130A

.subckt dd2_g5__nand2_1 A B VGND VNB VPB VPWR Y
X0 Y A VPWR VPB sky130_fd_pr__pfet_01v8_hvt ad=0.135 pd=1.27 as=0.26 ps=2.52 w=1 l=0.15
X1 VGND B a_111_47# VNB sky130_fd_pr__nfet_01v8 ad=0.169 pd=1.82 as=0.08775 ps=0.92 w=0.65 l=0.15
X2 a_111_47# A Y VNB sky130_fd_pr__nfet_01v8 ad=0.08775 pd=0.92 as=0.169 ps=1.82 w=0.65 l=0.15
X3 VPWR B Y VPB sky130_fd_pr__pfet_01v8_hvt ad=0.26 pd=2.52 as=0.135 ps=1.27 w=1 l=0.15
C0 VGND A 0.01452f
C1 B VPWR 0.02332f
C2 Y VPWR 0.02739f
C3 a_111_47# Y 0.00638f
C4 B VGND 0.02185f
C5 Y VGND 0.0318f
C6 VPB A 0.0375f
C7 a_111_47# VPWR 0.00107f
C8 VGND VPWR 0.02288f
C9 a_111_47# VGND 0.00762f
C10 B VPB 0.02945f
C11 VPB Y 0.01133f
C12 B A 0.02626f
C13 Y A 0.0502f
C14 B Y 0.02458f
C15 VPB VPWR 0.0528f
C16 VPWR A 0.02625f
C17 VPB VGND 0.00859f
C18 VGND VNB 0.27151f
C19 Y VNB 0.1233f
C20 VPWR VNB 0.25117f
C21 VPB VNB 0.33898f
C22 a_111_47# VNB 0.04772f
.ends
