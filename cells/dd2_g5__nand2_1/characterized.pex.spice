* NGSPICE file created from dd2_g5__nand2_1.ext - technology: sky130A

.subckt dd2_g5__nand2_1 A B VGND VNB VPB VPWR Y
X0 Y.t0 A.t1 VPWR.t0 VPB.t1 sky130_fd_pr__pfet_01v8_hvt ad=0.135 pd=1.27 as=0.26 ps=2.52 w=1 l=0.15
X1 VGND.t0 B.t0 a_111_47.t0 VNB.t0 sky130_fd_pr__nfet_01v8 ad=0.169 pd=1.82 as=0.08775 ps=0.92 w=0.65 l=0.15
X2 a_111_47.t1 A.t0 Y.t1 VNB.t1 sky130_fd_pr__nfet_01v8 ad=0.08775 pd=0.92 as=0.169 ps=1.82 w=0.65 l=0.15
X3 VPWR.t1 B.t1 Y.t2 VPB.t0 sky130_fd_pr__pfet_01v8_hvt ad=0.26 pd=2.52 as=0.135 ps=1.27 w=1 l=0.15
R0 VGND.n0 VGND.t0 156.405
R1 VGND VGND.n0 13.9415
R2 VGND.n0 VGND 0.467001
R3 Y.n1 Y.n0 269.041
R4 Y.n1 Y.t1 132.704
R5 Y.n0 Y.t2 26.5955
R6 Y.n0 Y.t0 26.5955
R7 Y Y.n1 2.29184
R8 VPWR VPWR.t0 347.193
R9 VPWR.n1 VPWR.t1 264.842
R10 VPWR.n1 VPWR.n0 37.1366
R11 VPWR.n3 VPWR.n2 9.3005
R12 VPWR VPWR.n3 6.77697
R13 VPWR.n3 VPWR.n0 3.01226
R14 VPWR.n2 VPWR.n1 2.28766
R15 VPWR.n0 VPWR 0.376971
R16 VPWR.n2 VPWR 0.0239375
R17 B.n0 B.t1 241.536
R18 B.n0 B.t0 169.237
R19 B B.n0 155.103
R20 A.n0 A.t1 230.155
R21 A.n0 A.t0 157.856
R22 A A.n0 155.103
R23 VPB.t1 VPB.t0 248.599
R24 VPB VPB.t1 201.246
R25 VNB.t1 VNB.t0 1196.12
R26 VNB VNB.t1 968.285
R27 a_111_47.t0 a_111_47.t1 49.8467
C0 B Y 0.03327f
C1 B VPB 0.02945f
C2 B VGND 0.02642f
C3 B VPWR 0.02635f
C4 A Y 0.05969f
C5 A VPB 0.0375f
C6 A VGND 0.01368f
C7 VPB Y 0.00909f
C8 A VPWR 0.02686f
C9 VGND Y 0.05186f
C10 VPB VGND 0.00717f
C11 Y VPWR 0.09774f
C12 VPB VPWR 0.0573f
C13 VGND VPWR 0.02165f
C14 A B 0.02626f
C15 VGND VNB 0.30089f
C16 Y VNB 0.08936f
C17 VPWR VNB 0.26258f
C18 B VNB 0.11236f
C19 A VNB 0.12981f
C20 VPB VNB 0.3789f
C21 a_111_47.t1 VNB 0.02619f
C22 a_111_47.t0 VNB 0.02588f
C23 VPB.t0 VNB 0.07026f
C24 VPB.t1 VNB 0.03034f
C25 A.n0 VNB 0.06628f
C26 B.n0 VNB 0.04616f
C27 VPWR.t0 VNB 0.05699f
C28 VPWR.n0 VNB 0.00662f
C29 VPWR.t1 VNB 0.05875f
C30 VPWR.n1 VNB 0.04498f
C31 VPWR.n2 VNB 0.07375f
C32 VPWR.n3 VNB 0.00146f
C33 Y.t2 VNB 0.0392f
C34 Y.t0 VNB 0.03966f
C35 Y.n0 VNB 0.05622f
C36 Y.t1 VNB 0.04922f
C37 Y.n1 VNB 0.10907f
C38 VGND.t0 VNB 0.03411f
C39 VGND.n0 VNB 0.0458f
.ends
