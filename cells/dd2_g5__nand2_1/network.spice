* dd2_g5__nand2_1: Y = !A | !B
* Generated by synthesize.py; stages in signal order:
*   Y = !(A & B)
.subckt dd2_g5__nand2_1 A B VGND VNB VPB VPWR Y
XN1 Y A Y_d1 VNB sky130_fd_pr__nfet_01v8 w=0.65 l=0.15
XN2 Y_d1 B VGND VNB sky130_fd_pr__nfet_01v8 w=0.65 l=0.15
XP1 Y A VPWR VPB sky130_fd_pr__pfet_01v8_hvt w=1 l=0.15
XP2 Y B VPWR VPB sky130_fd_pr__pfet_01v8_hvt w=1 l=0.15
.ends dd2_g5__nand2_1
