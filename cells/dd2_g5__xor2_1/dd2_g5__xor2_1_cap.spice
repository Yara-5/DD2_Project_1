* NGSPICE file created from dd2_g5__xor2_1.ext - technology: sky130A

.subckt dd2_g5__xor2_1 A B VGND VNB VPB VPWR Y
X0 a_111_297# B a_29_297# VPB sky130_fd_pr__pfet_01v8_hvt ad=0.135 pd=1.27 as=0.26 ps=2.52 w=1 l=0.15
X1 Y a_29_297# VGND VNB sky130_fd_pr__nfet_01v8 ad=0.10725 pd=0.98 as=0.10725 ps=0.98 w=0.65 l=0.15
X2 VGND A a_29_297# VNB sky130_fd_pr__nfet_01v8 ad=0.10725 pd=0.98 as=0.08775 ps=0.92 w=0.65 l=0.15
X3 a_29_297# B VGND VNB sky130_fd_pr__nfet_01v8 ad=0.08775 pd=0.92 as=0.169 ps=1.82 w=0.65 l=0.15
X4 VGND A a_387_47# VNB sky130_fd_pr__nfet_01v8 ad=0.169 pd=1.82 as=0.08775 ps=0.92 w=0.65 l=0.15
X5 a_387_47# B Y VNB sky130_fd_pr__nfet_01v8 ad=0.08775 pd=0.92 as=0.10725 ps=0.98 w=0.65 l=0.15
X6 a_291_297# A Y VPB sky130_fd_pr__pfet_01v8_hvt ad=0.26 pd=2.52 as=0.135 ps=1.27 w=1 l=0.15
X7 a_291_297# a_29_297# VPWR VPB sky130_fd_pr__pfet_01v8_hvt ad=0.165 pd=1.33 as=0.165 ps=1.33 w=1 l=0.15
X8 VPWR A a_111_297# VPB sky130_fd_pr__pfet_01v8_hvt ad=0.165 pd=1.33 as=0.135 ps=1.27 w=1 l=0.15
X9 Y B a_291_297# VPB sky130_fd_pr__pfet_01v8_hvt ad=0.135 pd=1.27 as=0.165 ps=1.33 w=1 l=0.15
C0 a_29_297# a_111_297# 0.00533f
C1 VPWR VGND 0.00654f
C2 Y a_111_297# 0
C3 B a_111_297# 0.01179f
C4 VGND A 0.06516f
C5 a_29_297# VPB 0.03829f
C6 a_29_297# a_387_47# 0
C7 Y a_29_297# 0.01718f
C8 a_29_297# B 0.15894f
C9 VPWR a_291_297# 0.08246f
C10 Y VPB 0.01398f
C11 Y a_387_47# 0.00832f
C12 VPB B 0.07316f
C13 a_387_47# B 0
C14 VGND a_111_297# 0
C15 Y B 0.05192f
C16 a_291_297# A 0.01271f
C17 a_29_297# VGND 0.071f
C18 VPB VGND 0.00566f
C19 a_387_47# VGND 0.00763f
C20 Y VGND 0.0746f
C21 VGND B 0.04371f
C22 a_29_297# a_291_297# 0.00305f
C23 VPB a_291_297# 0.00748f
C24 a_291_297# a_387_47# 0
C25 Y a_291_297# 0.03325f
C26 a_291_297# B 0.03755f
C27 VPWR A 0.04838f
C28 VPWR a_111_297# 0.00793f
C29 a_291_297# VGND 0
C30 A a_111_297# 0
C31 VPWR a_29_297# 0.03796f
C32 VPWR VPB 0.07151f
C33 VPWR Y 0.01252f
C34 VPWR B 0.07277f
C35 a_29_297# A 0.12088f
C36 VPB A 0.0574f
C37 a_387_47# A 0.00205f
C38 Y A 0.09148f
C39 B A 0.13985f
C40 VGND VNB 0.54069f
C41 Y VNB 0.1851f
C42 VPWR VNB 0.32522f
C43 VPB VNB 0.60476f
C44 a_291_297# VNB 0.04518f
C45 a_111_297# VNB 0.10119f
.ends
