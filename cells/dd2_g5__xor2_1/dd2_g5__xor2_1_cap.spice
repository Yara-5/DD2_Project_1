* NGSPICE file created from dd2_g5__xor2_1.ext - technology: sky130A

.subckt dd2_g5__xor2_1 A B VGND VNB VPB VPWR Y
X0 a_111_297# B a_29_297# VPB sky130_fd_pr__pfet_01v8_hvt ad=0.135 pd=1.27 as=0.26 ps=2.52 w=1 l=0.15
X1 Y a_29_297# VGND VNB sky130_fd_pr__nfet_01v8 ad=0.10725 pd=0.98 as=0.10725 ps=0.98 w=0.65 l=0.15
X2 VGND A a_29_297# VNB sky130_fd_pr__nfet_01v8 ad=0.10725 pd=0.98 as=0.08775 ps=0.92 w=0.65 l=0.15
X3 a_29_297# B VGND VNB sky130_fd_pr__nfet_01v8 ad=0.08775 pd=0.92 as=0.169 ps=1.82 w=0.65 l=0.15
X4 VGND A a_387_47# VNB sky130_fd_pr__nfet_01v8 ad=0.169 pd=1.82 as=0.08775 ps=0.92 w=0.65 l=0.15
X5 a_387_47# B Y VNB sky130_fd_pr__nfet_01v8 ad=0.08775 pd=0.92 as=0.10725 ps=0.98 w=0.65 l=0.15
X6 a_291_297# A Y VPB sky130_fd_pr__pfet_01v8_hvt ad=0.26 pd=2.52 as=0.135 ps=1.27 w=1 l=0.15
X7 a_291_297# a_29_297# VPWR VPB sky130_fd_pr__pfet_01v8_hvt ad=0.165 pd=1.33 as=0.165 ps=1.33 w=1 l=0.15
X8 VPWR A a_111_297# VPB sky130_fd_pr__pfet_01v8_hvt ad=0.165 pd=1.33 as=0.135 ps=1.27 w=1 l=0.15
X9 Y B a_291_297# VPB sky130_fd_pr__pfet_01v8_hvt ad=0.135 pd=1.27 as=0.165 ps=1.33 w=1 l=0.15
C0 Y B 0.06747f
C1 a_291_297# A 0.0674f
C2 a_29_297# VGND 0.08397f
C3 VPB VGND 0.00742f
C4 a_387_47# VGND 0.01295f
C5 Y VGND 0.05012f
C6 VGND B 0.06148f
C7 a_291_297# a_111_297# 0
C8 a_29_297# a_291_297# 0.00538f
C9 VPB a_291_297# 0.01149f
C10 a_291_297# a_387_47# 0
C11 Y a_291_297# 0.02996f
C12 a_291_297# B 0.0407f
C13 VPWR A 0.06799f
C14 VPWR a_111_297# 0.01f
C15 a_291_297# VGND 0.00569f
C16 A a_111_297# 0
C17 VPWR a_29_297# 0.05647f
C18 VPWR VPB 0.06702f
C19 VPWR Y 0.00224f
C20 VPWR B 0.06641f
C21 a_29_297# A 0.12625f
C22 VPB A 0.06135f
C23 a_387_47# A 0
C24 Y A 0.12537f
C25 B A 0.19402f
C26 a_29_297# a_111_297# 0.013f
C27 VPWR VGND 0.00677f
C28 B a_111_297# 0.00884f
C29 VGND A 0.06828f
C30 a_29_297# VPB 0.04233f
C31 a_29_297# a_387_47# 0
C32 Y a_29_297# 0.04008f
C33 a_29_297# B 0.16451f
C34 Y VPB 0.00465f
C35 VPWR a_291_297# 0.08593f
C36 Y a_387_47# 0.0081f
C37 VPB B 0.06876f
C38 a_387_47# B 0
C39 VGND a_111_297# 0
C40 VGND VNB 0.59025f
C41 Y VNB 0.14049f
C42 VPWR VNB 0.32894f
C43 VPB VNB 0.60476f
C44 a_291_297# VNB 0.07932f
C45 a_111_297# VNB 0.09489f
.ends
