* NGSPICE file created from sky130_fd_sc_hd__nor2_1.ext - technology: sky130A

.subckt sky130_fd_sc_hd__nor2_1 A B VGND VNB VPB VPWR Y
X0 VPWR.t0 A.t1 a_109_297.t0 VPB.t0 sky130_fd_pr__pfet_01v8_hvt ad=0.26 pd=2.52 as=0.105 ps=1.21 w=1 l=0.15
X1 VGND.t0 A.t0 Y.t0 VNB.t0 sky130_fd_pr__nfet_01v8 ad=0.169 pd=1.82 as=0.08775 ps=0.92 w=0.65 l=0.15
X2 a_109_297.t1 B.t1 Y.t1 VPB.t1 sky130_fd_pr__pfet_01v8_hvt ad=0.105 pd=1.21 as=0.26 ps=2.52 w=1 l=0.15
X3 Y.t2 B.t0 VGND.t1 VNB.t1 sky130_fd_pr__nfet_01v8 ad=0.08775 pd=0.92 as=0.169 ps=1.82 w=0.65 l=0.15
R0 VGND.n0 VGND.t1 163.721
R1 VGND.n0 VGND.t0 161.042
R2 VGND VGND.n0 0.489856
R3 VPWR VPWR.t0 250.668
R4 Y Y.n0 593.534
R5 Y.n2 Y.n0 289.24
R6 Y.n2 Y.n1 176.839
R7 Y.n0 Y.t1 26.5955
R8 Y.n1 Y.t0 24.9236
R9 Y.n1 Y.t2 24.9236
R10 Y Y.n2 11.176
R11 A.n0 A.t1 231.835
R12 A.n0 A.t0 157.07
R13 A A.n0 154.195
R14 B.n0 B.t1 230.363
R15 B B.n0 158.656
R16 B.n0 B.t0 158.064
R17 VPB.t1 VPB.t0 213.084
R18 VPB VPB.t1 189.409
R19 VNB.t1 VNB.t0 1196.12
R20 VNB VNB.t1 911.327
R21 a_109_297.t0 a_109_297.t1 41.3705
C0 VPB A 0.04146f
C1 B Y 0.06339f
C2 VPB VPWR 0.0536f
C3 VGND A 0.03932f
C4 VGND VPWR 0.01797f
C5 VPB B 0.0367f
C6 VGND B 0.03688f
C7 VPB Y 0.01392f
C8 VGND Y 0.08768f
C9 VPB VGND 0.00456f
C10 A VPWR 0.04414f
C11 B A 0.02921f
C12 B VPWR 0.01651f
C13 A Y 0.03679f
C14 Y VPWR 0.06054f
C15 VGND VNB 0.33287f
C16 VPWR VNB 0.37137f
C17 Y VNB 0.10239f
C18 A VNB 0.14482f
C19 B VNB 0.13781f
C20 VPB VNB 0.38166f
C21 a_109_297.t1 VNB 0.03677f
C22 a_109_297.t0 VNB 0.03722f
C23 VPB.t0 VNB 0.07853f
C24 VPB.t1 VNB 0.02902f
C25 B.n0 VNB 0.06984f
C26 A.n0 VNB 0.0759f
C27 Y.t1 VNB 0.04112f
C28 Y.n0 VNB 0.04714f
C29 Y.t0 VNB 0.02871f
C30 Y.t2 VNB 0.02849f
C31 Y.n1 VNB 0.05592f
C32 Y.n2 VNB 0.09085f
C33 VPWR.t0 VNB 0.06293f
C34 VGND.t0 VNB 0.03838f
C35 VGND.t1 VNB 0.03795f
C36 VGND.n0 VNB 0.07749f
.ends
