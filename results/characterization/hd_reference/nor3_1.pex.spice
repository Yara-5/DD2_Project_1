* NGSPICE file created from sky130_fd_sc_hd__nor3_1.ext - technology: sky130A

.subckt sky130_fd_sc_hd__nor3_1 A B C VGND VNB VPB VPWR Y
X0 VPWR.t0 A.t1 a_193_297.t0 VPB.t1 sky130_fd_pr__pfet_01v8_hvt ad=0.26 pd=2.52 as=0.135 ps=1.27 w=1 l=0.15
X1 a_193_297.t1 B.t1 a_109_297.t1 VPB.t2 sky130_fd_pr__pfet_01v8_hvt ad=0.135 pd=1.27 as=0.135 ps=1.27 w=1 l=0.15
X2 Y.t3 B.t0 VGND.t2 VNB.t2 sky130_fd_pr__nfet_01v8 ad=0.08775 pd=0.92 as=0.08775 ps=0.92 w=0.65 l=0.15
X3 VGND.t0 A.t0 Y.t0 VNB.t1 sky130_fd_pr__nfet_01v8 ad=0.169 pd=1.82 as=0.08775 ps=0.92 w=0.65 l=0.15
X4 a_109_297.t0 C.t1 Y.t1 VPB.t0 sky130_fd_pr__pfet_01v8_hvt ad=0.135 pd=1.27 as=0.26 ps=2.52 w=1 l=0.15
X5 VGND.t1 C.t0 Y.t2 VNB.t0 sky130_fd_pr__nfet_01v8 ad=0.08775 pd=0.92 as=0.169 ps=1.82 w=0.65 l=0.15
R0 VGND.n1 VGND.t0 284.839
R1 VGND.n1 VGND.n0 205.357
R2 VGND.n0 VGND.t2 24.9236
R3 VGND.n0 VGND.t1 24.9236
R4 VGND VGND.n1 0.636176
R5 VPWR VPWR.t0 345.317
R6 Y.n1 Y.t2 276.308
R7 Y.n2 Y.t1 223.165
R8 Y.n1 Y.n0 192.906
R9 Y.n2 Y.n1 169.601
R10 Y.n0 Y.t0 24.9236
R11 Y.n0 Y.t3 24.9236
R12 Y Y.n2 2.82553
R13 A.n0 A.t1 229.001
R14 A A.n0 170.964
R15 A.n0 A.t0 156.702
R16 B.n0 B.t1 241.536
R17 B.n0 B.t0 169.237
R18 B B.n0 165.246
R19 C.n0 C.t1 231.017
R20 C.n0 C.t0 158.716
R21 C C.n0 156.268
R22 VPB.t2 VPB.t1 248.599
R23 VPB.t0 VPB.t2 248.599
R24 VPB VPB.t0 189.409
R25 VNB.t2 VNB.t1 1196.12
R26 VNB.t0 VNB.t2 1196.12
R27 VNB VNB.t0 911.327
R28 a_193_297.t0 a_193_297.t1 53.1905
R29 a_109_297.t0 a_109_297.t1 53.1905
C0 Y A 0.07102f
C1 A VPWR 0.0397f
C2 VGND B 0.01915f
C3 Y VPWR 0.10729f
C4 B C 0.05179f
C5 VGND C 0.01667f
C6 VPB B 0.02859f
C7 VGND VPB 0.00466f
C8 A B 0.02828f
C9 VPB C 0.03686f
C10 Y B 0.11921f
C11 A VGND 0.03877f
C12 B VPWR 0.01296f
C13 Y VGND 0.09035f
C14 VGND VPWR 0.0225f
C15 Y C 0.06647f
C16 C VPWR 0.0094f
C17 A VPB 0.04359f
C18 Y VPB 0.01392f
C19 VPB VPWR 0.05275f
C20 VGND VNB 0.34901f
C21 VPWR VNB 0.4429f
C22 Y VNB 0.15307f
C23 A VNB 0.21758f
C24 B VNB 0.16693f
C25 C VNB 0.14476f
C26 VPB VNB 0.4682f
C27 a_109_297.t1 VNB 0.04102f
C28 a_109_297.t0 VNB 0.03537f
C29 a_193_297.t1 VNB 0.03994f
C30 a_193_297.t0 VNB 0.03263f
C31 VPB.t1 VNB 0.07556f
C32 VPB.t2 VNB 0.03412f
C33 VPB.t0 VNB 0.03006f
C34 C.n0 VNB 0.06534f
C35 B.n0 VNB 0.06178f
C36 A.n0 VNB 0.07159f
C37 Y.t1 VNB 0.09638f
C38 Y.t0 VNB 0.02911f
C39 Y.t3 VNB 0.03442f
C40 Y.n0 VNB 0.02683f
C41 Y.t2 VNB 0.07612f
C42 Y.n1 VNB 0.14833f
C43 Y.n2 VNB 0.08914f
C44 VPWR.t0 VNB 0.06112f
C45 VGND.t0 VNB 0.03335f
C46 VGND.t2 VNB 0.02594f
C47 VGND.t1 VNB 0.02183f
C48 VGND.n0 VNB 0.01089f
C49 VGND.n1 VNB 0.07217f
.ends
