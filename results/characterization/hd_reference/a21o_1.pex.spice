* NGSPICE file created from sky130_fd_sc_hd__a21o_1.ext - technology: sky130A

.subckt sky130_fd_sc_hd__a21o_1 A1 A2 B1 VGND VNB VPB VPWR X
X0 a_81_21.t0 B1.t0 VGND.t0 VNB.t0 sky130_fd_pr__nfet_01v8 ad=0.08937 pd=0.925 as=0.25675 ps=1.44 w=0.65 l=0.15
X1 a_299_297.t0 B1.t1 a_81_21.t1 VPB.t0 sky130_fd_pr__pfet_01v8_hvt ad=0.1375 pd=1.275 as=0.26 ps=2.52 w=1 l=0.15
X2 VPWR.t2 a_81_21.t4 X.t0 VPB.t1 sky130_fd_pr__pfet_01v8_hvt ad=0.26 pd=2.52 as=0.26 ps=2.52 w=1 l=0.15
X3 VPWR.t0 A1.t1 a_299_297.t2 VPB.t3 sky130_fd_pr__pfet_01v8_hvt ad=0.14 pd=1.28 as=0.1375 ps=1.275 w=1 l=0.15
X4 VGND.t2 a_81_21.t3 X.t1 VNB.t1 sky130_fd_pr__nfet_01v8 ad=0.25675 pd=1.44 as=0.169 ps=1.82 w=0.65 l=0.15
X5 VGND.t1 A2.t0 a_384_47.t0 VNB.t2 sky130_fd_pr__nfet_01v8 ad=0.17225 pd=1.83 as=0.091 ps=0.93 w=0.65 l=0.15
X6 a_299_297.t1 A2.t1 VPWR.t1 VPB.t2 sky130_fd_pr__pfet_01v8_hvt ad=0.265 pd=2.53 as=0.14 ps=1.28 w=1 l=0.15
X7 a_384_47.t1 A1.t0 a_81_21.t2 VNB.t3 sky130_fd_pr__nfet_01v8 ad=0.091 pd=0.93 as=0.08937 ps=0.925 w=0.65 l=0.15
R0 VGND.n4 VGND.t1 241.518
R1 VGND.n1 VGND.n0 185
R2 VGND.n3 VGND.n2 185
R3 VGND.n2 VGND.n1 62.7697
R4 VGND.n1 VGND.t2 41.539
R5 VGND.n2 VGND.t0 41.539
R6 VGND.n5 VGND.n0 9.66405
R7 VGND.n3 VGND.n0 8.05976
R8 VGND.n4 VGND.n3 7.96699
R9 VGND.n5 VGND.n4 0.254179
R10 VGND VGND.n5 0.121426
R11 VPWR.n1 VPWR.t2 342.221
R12 VPWR.n1 VPWR.n0 315.748
R13 VPWR.n0 VPWR.t1 27.5805
R14 VPWR.n0 VPWR.t0 27.5805
R15 VPWR VPWR.n1 0.214648
R16 X X.t0 759.912
R17 X.n1 X.t0 747.904
R18 X.n0 X.t1 209.923
R19 X.n1 X 16.2467
R20 X X.n0 9.84665
R21 X.n0 X 6.89281
R22 X X.n1 0.492808
R23 A2.n0 A2.t1 231.017
R24 A2.n0 A2.t0 158.716
R25 A2 A2.n0 154.56
R26 A1.n0 A1.t1 241.536
R27 A1.n0 A1.t0 169.237
R28 A1 A1.n0 157.575
R29 B1.n0 B1.t1 230.793
R30 B1.n0 B1.t0 158.494
R31 B1 B1.n0 157.988
R32 VPB.t1 VPB.t0 556.386
R33 VPB.t3 VPB.t2 254.518
R34 VPB.t0 VPB.t3 251.559
R35 VPB VPB.t1 201.246
R36 VNB.t1 VNB.t0 2677.02
R37 VNB.t3 VNB.t2 1224.6
R38 VNB.t0 VNB.t3 1210.36
R39 VNB VNB.t1 968.285
R40 a_384_47.t0 a_384_47.t1 51.6928
R41 a_299_297.n0 a_299_297.t1 719.394
R42 a_299_297.n0 a_299_297.t2 27.5805
R43 a_299_297.t0 a_299_297.n0 26.5955
R44 a_81_21.t1 a_81_21.n2 408.337
R45 a_81_21.n2 a_81_21.n0 251.718
R46 a_81_21.n1 a_81_21.t4 230.793
R47 a_81_21.n1 a_81_21.t3 158.494
R48 a_81_21.n2 a_81_21.n1 152
R49 a_81_21.n0 a_81_21.t2 25.8467
R50 a_81_21.n0 a_81_21.t0 24.9236
C0 B1 A1 0.04168f
C1 VPWR A2 0.02f
C2 VGND VPB 0.00713f
C3 VPWR A1 0.02095f
C4 B1 X 0
C5 VPWR X 0.05282f
C6 A2 A1 0.05177f
C7 B1 VPB 0.03872f
C8 B1 VGND 0.01814f
C9 VPWR VPB 0.0724f
C10 VPWR VGND 0.03167f
C11 A2 VPB 0.03733f
C12 VPB A1 0.02643f
C13 VGND A2 0.03782f
C14 VGND A1 0.05207f
C15 X VPB 0.01313f
C16 B1 VPWR 0.01815f
C17 VGND X 0.03765f
C18 VGND VNB 0.38985f
C19 VPWR VNB 0.37816f
C20 X VNB 0.17965f
C21 A2 VNB 0.1426f
C22 A1 VNB 0.18132f
C23 B1 VNB 0.12467f
C24 VPB VNB 0.64704f
C25 a_81_21.t2 VNB 0.03339f
C26 a_81_21.t0 VNB 0.03135f
C27 a_81_21.n0 VNB 0.04501f
C28 a_81_21.n1 VNB 0.05813f
C29 a_81_21.n2 VNB 0.23854f
C30 a_81_21.t1 VNB 0.09895f
C31 a_299_297.t2 VNB 0.0443f
C32 a_299_297.t1 VNB 0.14347f
C33 a_299_297.n0 VNB 0.11236f
C34 a_299_297.t0 VNB 0.04159f
C35 a_384_47.t1 VNB 0.02821f
C36 a_384_47.t0 VNB 0.02521f
C37 VPB.t2 VNB 0.07525f
C38 VPB.t3 VNB 0.03614f
C39 VPB.t0 VNB 0.0577f
C40 VPB.t1 VNB 0.05411f
C41 B1.n0 VNB 0.07408f
C42 A1.n0 VNB 0.0582f
C43 A2.n0 VNB 0.067f
C44 X.t0 VNB 0.05861f
C45 X.t1 VNB 0.04205f
C46 X.n0 VNB 0.01027f
C47 X.n1 VNB 0.01155f
C48 VPWR.t1 VNB 0.03529f
C49 VPWR.t0 VNB 0.0394f
C50 VPWR.n0 VNB 0.0246f
C51 VPWR.t2 VNB 0.06174f
C52 VPWR.n1 VNB 0.25259f
C53 VGND.n0 VNB 0.02181f
C54 VGND.t1 VNB 0.03744f
C55 VGND.t0 VNB 0.02691f
C56 VGND.t2 VNB 0.0231f
C57 VGND.n1 VNB 0.01971f
C58 VGND.n2 VNB 0.01971f
C59 VGND.n3 VNB 0.02228f
C60 VGND.n4 VNB 0.10894f
C61 VGND.n5 VNB 0.06161f
.ends
