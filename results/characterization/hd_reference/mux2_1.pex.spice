* NGSPICE file created from sky130_fd_sc_hd__mux2_1.ext - technology: sky130A

.subckt sky130_fd_sc_hd__mux2_1 A0 A1 S VGND VNB VPB VPWR X
X0 VPWR.t1 a_505_21.t3 a_535_374.t1 VPB.t3 sky130_fd_pr__pfet_01v8_hvt ad=0.0693 pd=0.75 as=0.0441 ps=0.63 w=0.42 l=0.15
X1 a_505_21.t1 S.t2 VPWR.t2 VPB.t5 sky130_fd_pr__pfet_01v8_hvt ad=0.1176 pd=1.4 as=0.0693 ps=0.75 w=0.42 l=0.15
X2 a_218_374.t1 S.t3 VPWR.t3 VPB.t4 sky130_fd_pr__pfet_01v8_hvt ad=0.07665 pd=0.785 as=0.15835 ps=1.395 w=0.42 l=0.15
X3 VGND.t3 a_505_21.t2 a_439_47.t1 VNB.t3 sky130_fd_pr__nfet_01v8 ad=0.1449 pd=1.11 as=0.0693 ps=0.75 w=0.42 l=0.15
X4 a_76_199.t0 A0.t1 a_218_374.t0 VPB.t0 sky130_fd_pr__pfet_01v8_hvt ad=0.1932 pd=1.34 as=0.07665 ps=0.785 w=0.42 l=0.15
X5 a_505_21.t0 S.t0 VGND.t0 VNB.t5 sky130_fd_pr__nfet_01v8 ad=0.1092 pd=1.36 as=0.1449 ps=1.11 w=0.42 l=0.15
X6 a_439_47.t0 A0.t0 a_76_199.t1 VNB.t0 sky130_fd_pr__nfet_01v8 ad=0.0693 pd=0.75 as=0.09975 ps=0.895 w=0.42 l=0.15
X7 a_535_374.t0 A1.t1 a_76_199.t2 VPB.t2 sky130_fd_pr__pfet_01v8_hvt ad=0.0441 pd=0.63 as=0.1932 ps=1.34 w=0.42 l=0.15
X8 a_76_199.t3 A1.t0 a_218_47.t0 VNB.t2 sky130_fd_pr__nfet_01v8 ad=0.09975 pd=0.895 as=0.0693 ps=0.75 w=0.42 l=0.15
X9 a_218_47.t1 S.t1 VGND.t1 VNB.t4 sky130_fd_pr__nfet_01v8 ad=0.0693 pd=0.75 as=0.11285 ps=1.045 w=0.42 l=0.15
X10 VPWR.t0 a_76_199.t5 X.t0 VPB.t1 sky130_fd_pr__pfet_01v8_hvt ad=0.15835 pd=1.395 as=0.26 ps=2.52 w=1 l=0.15
X11 VGND.t2 a_76_199.t4 X.t1 VNB.t1 sky130_fd_pr__nfet_01v8 ad=0.11285 pd=1.045 as=0.169 ps=1.82 w=0.65 l=0.15
R0 VGND.n13 VGND.n12 199.739
R1 VGND.n3 VGND.n2 187.565
R2 VGND.n5 VGND.n4 185
R3 VGND.n4 VGND.n3 97.1434
R4 VGND.n12 VGND.t1 74.2862
R5 VGND.n4 VGND.t3 61.4291
R6 VGND.n3 VGND.t0 38.5719
R7 VGND.n11 VGND.n10 34.6358
R8 VGND.n10 VGND.n1 34.6358
R9 VGND.n6 VGND.n1 34.6358
R10 VGND.n12 VGND.t2 25.4291
R11 VGND.n13 VGND.n11 22.9652
R12 VGND.n6 VGND.n5 22.2496
R13 VGND.n7 VGND.n6 9.3005
R14 VGND.n8 VGND.n1 9.3005
R15 VGND.n10 VGND.n9 9.3005
R16 VGND.n11 VGND.n0 9.3005
R17 VGND.n14 VGND.n13 7.12063
R18 VGND.n7 VGND.n2 5.59093
R19 VGND.n5 VGND.n2 3.03853
R20 VGND.n14 VGND.n0 0.148519
R21 VGND.n9 VGND.n0 0.120292
R22 VGND.n9 VGND.n8 0.120292
R23 VGND.n8 VGND.n7 0.120292
R24 VGND VGND.n14 0.11354
R25 A1.n0 A1.t0 414.432
R26 A1.n0 A1.t1 300.349
R27 A1 A1.n0 29.9794
R28 A0.n0 A0.t1 471.289
R29 A0 A0.n0 154.097
R30 A0.n0 A0.t0 148.35
R31 S S.n1 428.005
R32 S.n0 S.t0 329.902
R33 S.n1 S.t3 272.062
R34 S.n1 S.t1 206.19
R35 S S.n0 152.674
R36 S.n0 S.t2 148.35
R37 VPWR.n2 VPWR.n0 642.889
R38 VPWR.n2 VPWR.n1 242.226
R39 VPWR.n1 VPWR.t3 123.507
R40 VPWR.n0 VPWR.t1 86.7743
R41 VPWR.n0 VPWR.t2 68.0124
R42 VPWR.n1 VPWR.t0 28.752
R43 VPWR VPWR.n2 0.145102
R44 X.n2 X 593.407
R45 X.n3 X.n2 585
R46 X.n2 X.n0 585
R47 X.n1 X.t1 209.923
R48 X.n3 X.n1 74.3207
R49 X.n2 X.t0 26.5955
R50 X X.n0 8.40647
R51 X X.n3 4.58557
R52 X X.n0 4.58557
R53 X.n1 X 2.76128
R54 VPB.t0 VPB.t2 633.333
R55 VPB.t1 VPB.t4 322.587
R56 VPB.t4 VPB.t0 304.829
R57 VPB.t3 VPB.t5 284.113
R58 VPB.t2 VPB.t3 213.084
R59 VPB VPB.t1 59.1905
R60 VNB.t3 VNB.t5 2392.23
R61 VNB.t2 VNB.t0 1779.94
R62 VNB.t1 VNB.t4 1552.1
R63 VNB.t0 VNB.t3 1366.99
R64 VNB.t4 VNB.t2 1366.99
R65 VNB VNB.t1 142.395
R66 a_439_47.t0 a_439_47.t1 94.2862
R67 a_218_47.t0 a_218_47.t1 94.2862
R68 a_535_374.t0 a_535_374.t1 98.5005
R69 a_218_374.t0 a_218_374.t1 171.202
R70 a_505_21.n1 a_505_21.t1 703.471
R71 a_505_21.n0 a_505_21.t3 329.805
R72 a_505_21.t0 a_505_21.n1 246.56
R73 a_505_21.n0 a_505_21.t2 209.597
R74 a_505_21.n1 a_505_21.n0 202.071
R75 a_76_199.n3 a_76_199.n2 390.017
R76 a_76_199.n0 a_76_199.t5 241.536
R77 a_76_199.n2 a_76_199.n0 223.53
R78 a_76_199.n3 a_76_199.t2 214.52
R79 a_76_199.n2 a_76_199.n1 206.403
R80 a_76_199.t0 a_76_199.n3 194.49
R81 a_76_199.n0 a_76_199.t4 169.237
R82 a_76_199.n1 a_76_199.t1 94.2862
R83 a_76_199.n1 a_76_199.t3 41.4291
C0 VPB S 0.17119f
C1 A1 VPB 0.07263f
C2 X VPB 0.01205f
C3 VGND VPB 0.01346f
C4 A1 S 0.05309f
C5 A0 VPB 0.1066f
C6 X S 0.00584f
C7 VPB VPWR 0.12653f
C8 VGND S 0.03855f
C9 VGND A1 0.05051f
C10 A0 S 0.02207f
C11 S VPWR 0.24023f
C12 VGND X 0.03891f
C13 A1 A0 0.14666f
C14 A1 VPWR 0.01137f
C15 VGND A0 0.03291f
C16 X VPWR 0.07426f
C17 VGND VPWR 0.04293f
C18 A0 VPWR 0.00732f
C19 VGND VNB 0.52461f
C20 A1 VNB 0.20882f
C21 A0 VNB 0.25056f
C22 S VNB 0.5143f
C23 VPWR VNB 0.45596f
C24 X VNB 0.13568f
C25 VPB VNB 0.95574f
C26 a_76_199.n0 VNB 0.06545f
C27 a_76_199.t1 VNB 0.04335f
C28 a_76_199.t3 VNB 0.06928f
C29 a_76_199.n1 VNB 0.03695f
C30 a_76_199.n2 VNB 0.22821f
C31 a_76_199.t2 VNB 0.07247f
C32 a_76_199.n3 VNB 0.08164f
C33 a_76_199.t0 VNB 0.07526f
C34 a_505_21.t1 VNB 0.06256f
C35 a_505_21.n0 VNB 0.06391f
C36 a_505_21.n1 VNB 0.22666f
C37 a_505_21.t0 VNB 0.06392f
C38 a_218_374.t1 VNB 0.03825f
C39 a_218_374.t0 VNB 0.04896f
C40 a_535_374.t1 VNB 0.02187f
C41 a_535_374.t0 VNB 0.03966f
C42 a_218_47.t1 VNB 0.03372f
C43 a_218_47.t0 VNB 0.06632f
C44 a_439_47.t1 VNB 0.02123f
C45 a_439_47.t0 VNB 0.02732f
C46 VPB.t5 VNB 0.15781f
C47 VPB.t3 VNB 0.05866f
C48 VPB.t2 VNB 0.09985f
C49 VPB.t0 VNB 0.11068f
C50 VPB.t4 VNB 0.07402f
C51 VPB.t1 VNB 0.04504f
C52 X.n0 VNB 0.01026f
C53 X.t1 VNB 0.0456f
C54 X.n1 VNB 0.02723f
C55 X.t0 VNB 0.03684f
C56 X.n2 VNB 0.03487f
C57 X.n3 VNB 0.02686f
C58 VPWR.t2 VNB 0.02888f
C59 VPWR.t1 VNB 0.02503f
C60 VPWR.n0 VNB 0.01424f
C61 VPWR.t3 VNB 0.04056f
C62 VPWR.t0 VNB 0.02786f
C63 VPWR.n1 VNB 0.04864f
C64 VPWR.n2 VNB 0.47161f
C65 S.n0 VNB 0.08951f
C66 S.n1 VNB 0.21417f
C67 A0.n0 VNB 0.10112f
C68 A1.n0 VNB 0.21315f
C69 VGND.n0 VNB 0.03068f
C70 VGND.n1 VNB 0.00913f
C71 VGND.n2 VNB 0.03132f
C72 VGND.t0 VNB 0.03758f
C73 VGND.n3 VNB 0.01193f
C74 VGND.t3 VNB 0.02013f
C75 VGND.n4 VNB 0.0136f
C76 VGND.n5 VNB 0.01903f
C77 VGND.n6 VNB 0.00772f
C78 VGND.n7 VNB 0.11304f
C79 VGND.n8 VNB 0.02577f
C80 VGND.n9 VNB 0.02577f
C81 VGND.n10 VNB 0.00913f
C82 VGND.n11 VNB 0.00759f
C83 VGND.t1 VNB 0.03321f
C84 VGND.t2 VNB 0.02325f
C85 VGND.n12 VNB 0.01539f
C86 VGND.n13 VNB 0.0292f
C87 VGND.n14 VNB 0.02459f
.ends
