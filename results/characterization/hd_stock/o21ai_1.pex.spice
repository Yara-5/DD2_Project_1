* NGSPICE file created from sky130_fd_sc_hd__o21ai_1.ext - technology: sky130A

.subckt sky130_fd_sc_hd__o21ai_1 A1 A2 B1 VGND VNB VPB VPWR Y
X0 Y.t2 A2.t1 a_109_297.t1 VPB.t2 sky130_fd_pr__pfet_01v8_hvt ad=0.174 pd=1.39 as=0.105 ps=1.21 w=1 l=0.15
X1 VPWR.t0 B1.t1 Y.t1 VPB.t1 sky130_fd_pr__pfet_01v8_hvt ad=0.182 pd=1.92 as=0.174 ps=1.39 w=0.7 l=0.15
X2 a_27_47.t2 A2.t0 VGND.t0 VNB.t2 sky130_fd_pr__nfet_01v8 ad=0.08775 pd=0.92 as=0.10725 ps=0.98 w=0.65 l=0.15
X3 Y.t0 B1.t0 a_27_47.t1 VNB.t1 sky130_fd_pr__nfet_01v8 ad=0.169 pd=1.82 as=0.08775 ps=0.92 w=0.65 l=0.15
X4 a_109_297.t0 A1.t1 VPWR.t1 VPB.t0 sky130_fd_pr__pfet_01v8_hvt ad=0.105 pd=1.21 as=0.26 ps=2.52 w=1 l=0.15
X5 VGND.t1 A1.t0 a_27_47.t0 VNB.t0 sky130_fd_pr__nfet_01v8 ad=0.10725 pd=0.98 as=0.169 ps=1.82 w=0.65 l=0.15
R0 VGND VGND.n0 204.819
R1 VGND.n0 VGND.t1 36.0005
R2 VGND.n0 VGND.t0 24.9236
R3 Y.n0 Y 593.534
R4 Y.n1 Y.n0 585
R5 Y Y.t0 305.063
R6 Y.n0 Y.t2 56.9025
R7 Y.n0 Y.t1 46.4362
R8 Y.n2 Y.n1 8.33989
R9 Y.n1 Y 4.65505
R10 Y Y.n2 0.194439
R11 Y.n2 Y 0.183357
R12 VPWR.n0 VPWR.t0 361.24
R13 VPWR.n0 VPWR.t1 251.102
R14 VPWR VPWR.n0 0.142966
R15 B1.n0 B1.t0 254.256
R16 B1.n0 B1.t1 181.956
R17 B1 B1.n0 154.845
R18 A2.n0 A2.t1 240.484
R19 A2.n0 A2.t0 168.185
R20 A2.n1 A2.n0 159.952
R21 A2 A2.n1 7.54922
R22 A2.n1 A2 2.90959
R23 A1.n0 A1.t1 234.483
R24 A1.n0 A1.t0 162.184
R25 A1 A1.n0 158.788
R26 VPB.t2 VPB.t1 319.627
R27 VPB.t0 VPB.t2 213.084
R28 VPB VPB.t0 189.409
R29 VNB.t0 VNB.t2 1366.99
R30 VNB.t2 VNB.t1 1196.12
R31 VNB VNB.t0 911.327
R32 a_27_47.t0 a_27_47.n0 471.692
R33 a_27_47.n0 a_27_47.t1 24.9236
R34 a_27_47.n0 a_27_47.t2 24.9236
R35 a_109_297.t0 a_109_297.t1 41.3705
C0 VPB B1 0.0741f
C1 A1 VPB 0.03265f
C2 B1 VGND 0.01523f
C3 VPB A2 0.03045f
C4 A1 VGND 0.0163f
C5 VPB VPWR 0.06005f
C6 A2 VGND 0.01829f
C7 VPWR VGND 0.02097f
C8 B1 A2 0.02398f
C9 VPB Y 0.00672f
C10 A1 A2 0.05605f
C11 B1 VPWR 0.03655f
C12 A1 VPWR 0.03903f
C13 Y VGND 0.02272f
C14 VPWR A2 0.06615f
C15 B1 Y 0.06203f
C16 A1 Y 0
C17 VPB VGND 0.00462f
C18 Y A2 0.07048f
C19 Y VPWR 0.0646f
C20 VGND VNB 0.41508f
C21 Y VNB 0.1576f
C22 VPWR VNB 0.34913f
C23 B1 VNB 0.1523f
C24 A2 VNB 0.1483f
C25 A1 VNB 0.1324f
C26 VPB VNB 0.47474f
C27 a_109_297.t1 VNB 0.03859f
C28 a_109_297.t0 VNB 0.03269f
C29 a_27_47.t1 VNB 0.03625f
C30 a_27_47.t2 VNB 0.03329f
C31 a_27_47.n0 VNB 0.07382f
C32 a_27_47.t0 VNB 0.10543f
C33 VPB.t1 VNB 0.08774f
C34 VPB.t2 VNB 0.04245f
C35 VPB.t0 VNB 0.03208f
C36 A1.n0 VNB 0.06055f
C37 A2.n0 VNB 0.06406f
C38 A2.n1 VNB 0.04664f
C39 B1.n0 VNB 0.08732f
C40 VPWR.t0 VNB 0.04772f
C41 VPWR.t1 VNB 0.06264f
C42 VPWR.n0 VNB 0.15123f
C43 Y.t0 VNB 0.07369f
C44 Y.t1 VNB 0.03628f
C45 Y.t2 VNB 0.05575f
C46 Y.n0 VNB 0.04321f
C47 Y.n1 VNB 0.01296f
C48 Y.n2 VNB 0.00872f
C49 VGND.t0 VNB 0.02759f
C50 VGND.t1 VNB 0.02573f
C51 VGND.n0 VNB 0.01509f
.ends
