* NGSPICE file created from sky130_fd_sc_hd__inv_1.ext - technology: sky130A

.subckt sky130_fd_sc_hd__inv_1 A VGND VNB VPB VPWR Y
X0 Y.t1 A.t0 VGND.t0 VNB.t0 sky130_fd_pr__nfet_01v8 ad=0.169 pd=1.82 as=0.169 ps=1.82 w=0.65 l=0.15
X1 Y.t0 A.t1 VPWR.t0 VPB.t0 sky130_fd_pr__pfet_01v8_hvt ad=0.26 pd=2.52 as=0.26 ps=2.52 w=1 l=0.15
R0 VGND VGND.t0 166.952
R1 Y.n0 Y.t0 235.56
R2 Y Y.t1 152.612
R3 Y Y.n0 2.50485
R4 Y.n0 Y 1.74595
R5 VPWR VPWR.t0 264.904
R6 A.n0 A.t1 230.576
R7 A A.n0 158.667
R8 A.n0 A.t0 158.275
R9 VPB VPB.t0 348.154
R10 VNB VNB.t0 1600
C0 VPB VPWR 0.06649f
C1 VGND Y 0.05975f
C2 VPB A 0.04506f
C3 A VPWR 0.03629f
C4 VPB Y 0.01774f
C5 VPB VGND 0.01319f
C6 VPWR Y 0.07413f
C7 VPWR VGND 0.01841f
C8 A Y 0.03773f
C9 A VGND 0.03709f
C10 VGND VNB 0.35679f
C11 Y VNB 0.15401f
C12 VPWR VNB 0.36244f
C13 A VNB 0.1554f
C14 VPB VNB 0.39246f
C15 VPB.t0 VNB 0.089f
C16 A.n0 VNB 0.06028f
C17 VPWR.t0 VNB 0.06075f
C18 Y.t0 VNB 0.06566f
C19 Y.n0 VNB 0.05858f
C20 Y.t1 VNB 0.0442f
C21 VGND.t0 VNB 0.03408f
.ends
