* NGSPICE file created from sky130_fd_sc_hd__nand3_1.ext - technology: sky130A

.subckt sky130_fd_sc_hd__nand3_1 A B C VGND VNB VPB VPWR Y
X0 VPWR.t2 B.t1 Y.t3 VPB.t2 sky130_fd_pr__pfet_01v8_hvt ad=0.165 pd=1.33 as=0.135 ps=1.27 w=1 l=0.15
X1 Y.t0 A.t1 VPWR.t0 VPB.t1 sky130_fd_pr__pfet_01v8_hvt ad=0.26 pd=2.52 as=0.165 ps=1.33 w=1 l=0.15
X2 a_193_47.t1 B.t0 a_109_47.t1 VNB.t2 sky130_fd_pr__nfet_01v8 ad=0.10725 pd=0.98 as=0.08775 ps=0.92 w=0.65 l=0.15
X3 Y.t1 A.t0 a_193_47.t0 VNB.t1 sky130_fd_pr__nfet_01v8 ad=0.169 pd=1.82 as=0.10725 ps=0.98 w=0.65 l=0.15
X4 Y.t2 C.t1 VPWR.t1 VPB.t0 sky130_fd_pr__pfet_01v8_hvt ad=0.135 pd=1.27 as=0.26 ps=2.52 w=1 l=0.15
X5 a_109_47.t0 C.t0 VGND.t0 VNB.t0 sky130_fd_pr__nfet_01v8 ad=0.08775 pd=0.92 as=0.169 ps=1.82 w=0.65 l=0.15
R0 VGND VGND.t0 282.123
R1 Y.n1 Y.t0 274.793
R2 Y.n1 Y.n0 205.28
R3 Y Y.t1 169.452
R4 Y Y.n1 67.4857
R5 Y.n0 Y.t3 26.5955
R6 Y.n0 Y.t2 26.5955
R7 VPWR.n1 VPWR.n0 324.12
R8 VPWR.n1 VPWR.t1 256.774
R9 VPWR.n0 VPWR.t0 38.4155
R10 VPWR.n0 VPWR.t2 26.5955
R11 VPWR VPWR.n1 0.418937
R12 A.n0 A.t1 232.214
R13 A.n0 A.t0 159.915
R14 A A.n0 154.477
R15 B.n0 B.t1 241.536
R16 B.n0 B.t0 169.237
R17 B B.n0 154.744
R18 C.n0 C.t1 230.363
R19 C.n0 C.t0 158.064
R20 C C.n0 154.097
R21 VPB.t2 VPB.t1 284.113
R22 VPB.t0 VPB.t2 248.599
R23 VPB VPB.t0 189.409
R24 VNB.t2 VNB.t1 1366.99
R25 VNB.t0 VNB.t2 1196.12
R26 VNB VNB.t0 911.327
R27 a_193_47.t0 a_193_47.t1 60.9236
R28 a_109_47.t0 a_109_47.t1 49.8467
C0 VGND Y 0.11693f
C1 VGND C 0.03364f
C2 VPWR VGND 0.0233f
C3 Y C 0.04963f
C4 VPWR Y 0.18487f
C5 B VGND 0.01159f
C6 VPWR C 0.03597f
C7 VGND VPB 0.00519f
C8 VGND A 0.0099f
C9 B Y 0.09271f
C10 B C 0.02548f
C11 Y VPB 0.01658f
C12 B VPWR 0.01942f
C13 C VPB 0.03732f
C14 VPWR VPB 0.05586f
C15 A Y 0.06625f
C16 VPWR A 0.0185f
C17 B VPB 0.02678f
C18 B A 0.04466f
C19 A VPB 0.03683f
C20 VGND VNB 0.44357f
C21 Y VNB 0.22439f
C22 VPWR VNB 0.36753f
C23 A VNB 0.14131f
C24 B VNB 0.13922f
C25 C VNB 0.16236f
C26 VPB VNB 0.46779f
C27 a_109_47.t1 VNB 0.02609f
C28 a_109_47.t0 VNB 0.02285f
C29 a_193_47.t1 VNB 0.02841f
C30 a_193_47.t0 VNB 0.02578f
C31 VPB.t1 VNB 0.07239f
C32 VPB.t2 VNB 0.03619f
C33 VPB.t0 VNB 0.02976f
C34 C.n0 VNB 0.06452f
C35 B.n0 VNB 0.05536f
C36 A.n0 VNB 0.06235f
C37 VPWR.t0 VNB 0.03839f
C38 VPWR.t2 VNB 0.03751f
C39 VPWR.n0 VNB 0.0275f
C40 VPWR.t1 VNB 0.0648f
C41 VPWR.n1 VNB 0.11862f
C42 Y.t1 VNB 0.07099f
C43 Y.t0 VNB 0.10525f
C44 Y.t3 VNB 0.04512f
C45 Y.t2 VNB 0.04067f
C46 Y.n0 VNB 0.03941f
C47 Y.n1 VNB 0.19661f
C48 VGND.t0 VNB 0.0392f
.ends
