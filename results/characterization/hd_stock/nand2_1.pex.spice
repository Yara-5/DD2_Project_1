* NGSPICE file created from sky130_fd_sc_hd__nand2_1.ext - technology: sky130A

.subckt sky130_fd_sc_hd__nand2_1 A B VGND VNB VPB VPWR Y
X0 VPWR.t0 A.t1 Y.t1 VPB.t0 sky130_fd_pr__pfet_01v8_hvt ad=0.26 pd=2.52 as=0.135 ps=1.27 w=1 l=0.15
X1 Y.t0 A.t0 a_113_47.t0 VNB.t0 sky130_fd_pr__nfet_01v8 ad=0.169 pd=1.82 as=0.08775 ps=0.92 w=0.65 l=0.15
X2 a_113_47.t1 B.t0 VGND.t0 VNB.t1 sky130_fd_pr__nfet_01v8 ad=0.08775 pd=0.92 as=0.169 ps=1.82 w=0.65 l=0.15
X3 Y.t2 B.t1 VPWR.t1 VPB.t1 sky130_fd_pr__pfet_01v8_hvt ad=0.135 pd=1.27 as=0.26 ps=2.52 w=1 l=0.15
R0 VGND VGND.t0 158.046
R1 Y Y.n0 237.953
R2 Y.n1 Y.t0 140.53
R3 Y.n0 Y.t1 26.5955
R4 Y.n0 Y.t2 26.5955
R5 Y.n1 Y 16.1887
R6 Y Y.n1 9.41227
R7 Y.n1 Y 1.72748
R8 VPWR.n0 VPWR.t0 256.344
R9 VPWR.n0 VPWR.t1 254.13
R10 VPWR VPWR.n0 0.493374
R11 A.n0 A.t1 230.155
R12 A.n0 A.t0 157.856
R13 A A.n0 154.293
R14 B.n0 B.t1 229.369
R15 B B.n0 157.927
R16 B.n0 B.t0 157.07
R17 VPB.t1 VPB.t0 248.599
R18 VPB VPB.t1 207.166
R19 VNB.t1 VNB.t0 1196.12
R20 VNB VNB.t1 996.764
R21 a_113_47.t0 a_113_47.t1 49.8467
C0 VPB Y 0.00618f
C1 VPB A 0.03788f
C2 B VGND 0.04166f
C3 VPB VPWR 0.05574f
C4 A Y 0.06225f
C5 VPB VGND 0.0044f
C6 VPWR Y 0.1173f
C7 A VPWR 0.03737f
C8 B VPB 0.03907f
C9 VGND Y 0.0866f
C10 A VGND 0.00949f
C11 B Y 0.03697f
C12 VGND VPWR 0.01852f
C13 B A 0.02548f
C14 B VPWR 0.0398f
C15 VGND VNB 0.37196f
C16 Y VNB 0.14428f
C17 VPWR VNB 0.3207f
C18 A VNB 0.13589f
C19 B VNB 0.141f
C20 VPB VNB 0.38009f
C21 a_113_47.t1 VNB 0.02324f
C22 a_113_47.t0 VNB 0.02265f
C23 VPB.t0 VNB 0.07082f
C24 VPB.t1 VNB 0.03134f
C25 B.n0 VNB 0.07132f
C26 A.n0 VNB 0.06628f
C27 VPWR.t0 VNB 0.06042f
C28 VPWR.t1 VNB 0.06127f
C29 VPWR.n0 VNB 0.11432f
C30 Y.t1 VNB 0.0399f
C31 Y.t2 VNB 0.04072f
C32 Y.n0 VNB 0.048f
C33 Y.t0 VNB 0.05352f
C34 Y.n1 VNB 0.11237f
C35 VGND.t0 VNB 0.03981f
.ends
