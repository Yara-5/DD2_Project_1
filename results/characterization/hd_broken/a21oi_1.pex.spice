* NGSPICE file created from sky130_fd_sc_hd__a21oi_1.ext - technology: sky130A

.subckt sky130_fd_sc_hd__a21oi_1 A1 A2 B1 VGND VNB VPB VPWR Y
X0 a_199_47.t1 A1.t0 Y.t1 VNB.t2 sky130_fd_pr__nfet_01v8 ad=0.09588 pd=0.945 as=0.091 ps=0.93 w=0.65 l=0.15
X1 a_113_297.t1 A2.t1 VPWR.t1 VPB.t1 sky130_fd_pr__pfet_01v8_hvt ad=0.265 pd=2.53 as=0.1475 ps=1.295 w=1 l=0.15
X2 Y.t2 B1.t0 VGND.t1 VNB.t0 sky130_fd_pr__nfet_01v8 ad=0.091 pd=0.93 as=0.17225 ps=1.83 w=0.65 l=0.15
X3 VPWR.t0 A1.t1 a_113_297.t2 VPB.t2 sky130_fd_pr__pfet_01v8_hvt ad=0.1475 pd=1.295 as=0.14 ps=1.28 w=1 l=0.15
X4 a_113_297.t0 B1.t1 Y.t0 VPB.t0 sky130_fd_pr__pfet_01v8_hvt ad=0.14 pd=1.28 as=0.265 ps=2.53 w=1 l=0.15
X5 VGND.t0 A2.t0 a_199_47.t0 VNB.t1 sky130_fd_pr__nfet_01v8 ad=0.17225 pd=1.83 as=0.09588 ps=0.945 w=0.65 l=0.15
R0 VGND.n0 VGND.t1 288
R1 VGND.n0 VGND.t0 240.708
R2 VGND VGND.n0 0.162046
R3 VPWR VPWR.n0 614.966
R4 VPWR.n0 VPWR.t1 30.5355
R5 VPWR.n0 VPWR.t0 27.5805
R6 Y.n0 Y.t0 358.339
R7 Y Y.n1 270.058
R8 Y.n1 Y.t1 25.8467
R9 Y.n1 Y.t2 25.8467
R10 Y Y.n0 8.45358
R11 Y.n0 Y 7.23149
R12 A2.n0 A2.t1 231.017
R13 A2.n0 A2.t0 158.716
R14 A2 A2.n0 154.603
R15 A1.n0 A1.t1 241.536
R16 A1.n0 A1.t0 169.237
R17 A1 A1.n0 156.462
R18 B1.n0 B1.t1 229.369
R19 B1.n0 B1.t0 157.07
R20 B1 B1.n0 155.201
R21 VPB.t2 VPB.t1 263.397
R22 VPB.t0 VPB.t2 254.518
R23 VPB VPB.t0 207.166
R24 VNB.t2 VNB.t1 1267.31
R25 VNB.t0 VNB.t2 1224.6
R26 VNB VNB.t0 996.764
R27 a_199_47.t0 a_199_47.t1 54.462
R28 a_113_297.n0 a_113_297.t1 538.659
R29 a_113_297.n0 a_113_297.t2 27.5805
R30 a_113_297.t0 a_113_297.n0 27.5805
C0 A2 VGND 0.03772f
C1 VPB B1 0.03887f
C2 VPB VPWR 0.04551f
C3 A1 B1 0.02592f
C4 A1 VPWR 0.01539f
C5 Y B1 0.076f
C6 Y VPWR 0.03186f
C7 B1 VGND 0.0349f
C8 A2 VPWR 0.0147f
C9 VPWR VGND 0.0198f
C10 VPB A1 0.02639f
C11 VPB Y 0.01464f
C12 VPB A2 0.03728f
C13 A1 Y 0.04643f
C14 VPB VGND 0.00548f
C15 A2 A1 0.05114f
C16 VPWR B1 0.01343f
C17 A1 VGND 0.05137f
C18 A2 Y 0.00122f
C19 Y VGND 0.04248f
C20 VGND VNB 0.35272f
C21 VPWR VNB 0.41593f
C22 Y VNB 0.19315f
C23 A2 VNB 0.14125f
C24 A1 VNB 0.16897f
C25 B1 VNB 0.17687f
C26 VPB VNB 0.46828f
C27 a_113_297.t2 VNB 0.04236f
C28 a_113_297.t1 VNB 0.16172f
C29 a_113_297.n0 VNB 0.09647f
C30 a_113_297.t0 VNB 0.03712f
C31 a_199_47.t1 VNB 0.02884f
C32 a_199_47.t0 VNB 0.02546f
C33 VPB.t1 VNB 0.07154f
C34 VPB.t2 VNB 0.03527f
C35 VPB.t0 VNB 0.03144f
C36 B1.n0 VNB 0.06833f
C37 A1.n0 VNB 0.05774f
C38 A2.n0 VNB 0.06561f
C39 Y.t0 VNB 0.08046f
C40 Y.n0 VNB 0.0028f
C41 Y.t1 VNB 0.03225f
C42 Y.t2 VNB 0.02842f
C43 Y.n1 VNB 0.04103f
C44 VPWR.t1 VNB 0.03659f
C45 VPWR.t0 VNB 0.04f
C46 VPWR.n0 VNB 0.02492f
C47 VGND.t0 VNB 0.03722f
C48 VGND.t1 VNB 0.03467f
C49 VGND.n0 VNB 0.09888f
.ends
